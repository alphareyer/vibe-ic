* Declared functional circuit, not extracted parasitics or a PDK model
.subckt receiver din sense
Rfunctional din sense 1000
Cfunctional sense 0 10p
.ends receiver
