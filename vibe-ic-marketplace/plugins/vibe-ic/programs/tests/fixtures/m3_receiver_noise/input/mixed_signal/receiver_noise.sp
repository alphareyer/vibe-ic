* Open functional thermal-noise receiver; no extracted or PDK claim
.subckt receiver_noise din sense
Rthermal din sense 1000
Creceiver sense 0 10p
.ends receiver_noise
