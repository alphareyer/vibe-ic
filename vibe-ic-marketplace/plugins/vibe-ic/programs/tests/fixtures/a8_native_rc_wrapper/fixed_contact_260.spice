* NGSPICE file created from ldo_open.ext - technology: sky130A

.subckt sky130_fd_pr__res_high_po_0p35_PAVCDF B R1 R2
X0 R1.t0 R2.t0 B.t0 sky130_fd_pr__res_high_po_0p35 l=20
R0 R2 R2.t0 33.0976
R1 R2.t0 R2 1.933
R2 R1 R1.t0 33.0976
R3 R1.t0 R1.n0 2.10836
R4 B.n8 B.n3 15412.4
R5 B.n8 B.n2 15412.4
R6 B.n6 B.n3 15412.4
R7 B B.n1 1001.41
R8 B B.n0 1001.41
R9 B.n5 B.n1 1001.41
R10 B.n5 B.n0 1001.41
R11 B.n6 B.n5 292.5
R12 B.n8 B.t0 292.5
R13 B B.n8 292.5
R14 B.n7 B.n6 284.62
R15 B.n7 B.n2 130.613
R16 B.t0 B.n4 126.105
R17 B.n4 B 45.1593
R18 B.n2 B.n0 8.1255
R19 B.n4 B.n3 8.1255
R20 B.n3 B.n1 8.1255
R21 B.t0 B.n7 2.4798
C0 R2 B 0.46621f
C1 R1 B 0.46621f
.ends

.subckt sky130_fd_pr__nfet_01v8_XR83G9 B D S G
X0 S G D B.t0 sky130_fd_pr__nfet_01v8 ad=0.58 pd=4.58 as=0.58 ps=4.58 w=2 l=2
R0 B.n8 B.n3 3957.38
R1 B.n8 B.n2 3957.38
R2 B.n6 B.n3 3957.38
R3 B.t0 B.n4 1840.49
R4 B.n7 B.n2 1274.02
R5 B.n4 B 284.39
R6 B B.n1 257.13
R7 B B.n0 257.13
R8 B.n5 B.n1 257.13
R9 B.n5 B.n0 257.13
R10 B.n6 B.n5 73.1255
R11 B.n2 B.n0 73.1255
R12 B.n8 B.t0 73.1255
R13 B B.n8 73.1255
R14 B.n4 B.n3 73.1255
R15 B.n3 B.n1 73.1255
R16 B.n7 B.n6 48.685
R17 B.t0 B.n7 23.5424
C0 D G 0.14334f
C1 D S 0.03275f
C2 G S 0.14334f
C3 S B 0.71494f
C4 D B 0.71494f
.ends

.subckt sky130_fd_pr__res_high_po_0p35_5BEF7K B R1 R2
X0 R1.t0 R2.t0 B.t0 sky130_fd_pr__res_high_po_0p35 l=60
R0 R2 R2.t0 33.0976
R1 R2.t0 R2 1.933
R2 R1 R1.t0 33.0976
R3 R1.t0 R1.n0 2.10836
R4 B.n7 B.n3 38588.8
R5 B.n0 B.n1 54.701
R6 B.n6 B.n3 38588.8
R7 B B.n2 2507.29
R8 B B.n1 2507.29
R9 B.n5 B.n2 2507.29
R10 B.n5 B.n1 2507.29
R11 B.n6 B.n5 292.5
R12 B.n7 B.n0 289.913
R13 B B.n7 292.5
R14 B.t0 B.n6 289.909
R15 B.t0 B.n0 0.392283
R16 B.t0 B.n4 49.864
R17 B.n4 B 17.7155
R18 B.n4 B.n3 3.07945
R19 B.n3 B.n2 3.07945
C0 R2 B 0.46621f
C1 R1 B 0.46621f
.ends

.subckt sky130_fd_pr__nfet_01v8_AFE8E4 B D S G
X0 S G D B.t0 sky130_fd_pr__nfet_01v8 ad=1.16 pd=8.58 as=1.16 ps=8.58 w=4 l=2
R0 B.n8 B.n3 5116.21
R1 B.n8 B.n2 5116.21
R2 B.n6 B.n3 5116.21
R3 B.t0 B.n4 1237.05
R4 B.n7 B.n2 1011.54
R5 B B.n1 332.425
R6 B B.n0 332.425
R7 B.n5 B.n1 332.425
R8 B.n5 B.n0 332.425
R9 B.n4 B 191.149
R10 B.n6 B.n5 73.1255
R11 B.n8 B.t0 73.1255
R12 B B.n8 73.1255
R13 B.n7 B.n6 57.8416
R14 B.n2 B.n0 41.7862
R15 B.n4 B.n3 41.7862
R16 B.n3 B.n1 41.7862
R17 B.t0 B.n7 14.4587
C0 D G 0.2849f
C1 D S 0.06528f
C2 G S 0.2849f
C3 S B 0.9177f
C4 D B 0.9177f
.ends

.subckt sky130_fd_pr__nfet_01v8_TPXDG7 B D S G
X0 S G D B.t0 sky130_fd_pr__nfet_01v8 ad=2.32 pd=16.58 as=2.32 ps=16.58 w=8 l=1
R0 B.n8 B.n3 6854.44
R1 B.n8 B.n2 6854.44
R2 B.n6 B.n3 6854.44
R3 B.t0 B.n4 529.308
R4 B.n7 B.n2 502.753
R5 B B.n1 445.365
R6 B B.n0 445.365
R7 B.n5 B.n1 445.365
R8 B.n5 B.n0 445.365
R9 B.n6 B.n5 117.001
R10 B.n8 B.t0 117.001
R11 B B.n8 117.001
R12 B.n4 B 115.447
R13 B.n7 B.n6 106.6
R14 B.n2 B.n0 22.5005
R15 B.n4 B.n3 22.5005
R16 B.n3 B.n1 22.5005
R17 B.t0 B.n7 8.58259
C0 S D 0.23712f
C1 G D 0.43491f
C2 S G 0.43491f
C3 S B 1.03102f
C4 D B 1.03102f
.ends

.subckt sky130_fd_pr__pfet_01v8_5KKSJS B D S G VSUBS
X0 S G D B sky130_fd_pr__pfet_01v8 ad=1.16 pd=8.58 as=1.16 ps=8.58 w=4 l=1
C0 S D 0.11876f
C1 D B 0.2819f
C2 S B 0.2819f
C3 G D 0.21821f
C4 S G 0.21821f
C5 G B 0.45998f
C6 S VSUBS 0.17052f
C7 D VSUBS 0.17052f
C8 B VSUBS 2.79224f
.ends

.subckt sky130_fd_pr__pfet_01v8_FYEDVJ B D0 S0 G0 D1 S1 G1 D2 S2 G2 D3 S3 G3 D4 S4
+ G4 D5 S5 G5 D6 S6 G6 D7 S7 G7 D8 S8 G8 D9 S9 G9 D10 S10 G10 D11 S11 G11 D12 S12
+ G12 D13 S13 G13 D14 S14 G14 D15 S15 G15 D16 S16 G16 D17 S17 G17 D18 S18 G18 D19
+ S19 G19 VSUBS
X0 S17 G17 D17 B.t8 sky130_fd_pr__pfet_01v8 ad=1.45 pd=10.58 as=1.45 ps=10.58 w=5 l=0.5
X1 S5 G5 D5 B.t10 sky130_fd_pr__pfet_01v8 ad=1.45 pd=10.58 as=1.45 ps=10.58 w=5 l=0.5
X2 S3 G3 D3 B.t5 sky130_fd_pr__pfet_01v8 ad=1.45 pd=10.58 as=1.45 ps=10.58 w=5 l=0.5
X3 S12 G12 D12 B.t15 sky130_fd_pr__pfet_01v8 ad=1.45 pd=10.58 as=1.45 ps=10.58 w=5 l=0.5
X4 S10 G10 D10 B.t13 sky130_fd_pr__pfet_01v8 ad=1.45 pd=10.58 as=1.45 ps=10.58 w=5 l=0.5
X5 S16 G16 D16 B.t16 sky130_fd_pr__pfet_01v8 ad=1.45 pd=10.58 as=1.45 ps=10.58 w=5 l=0.5
X6 S14 G14 D14 B.t3 sky130_fd_pr__pfet_01v8 ad=1.45 pd=10.58 as=1.45 ps=10.58 w=5 l=0.5
X7 S6 G6 D6 B.t4 sky130_fd_pr__pfet_01v8 ad=1.45 pd=10.58 as=1.45 ps=10.58 w=5 l=0.5
X8 S8 G8 D8 B.t11 sky130_fd_pr__pfet_01v8 ad=1.45 pd=10.58 as=1.45 ps=10.58 w=5 l=0.5
X9 S19 G19 D19 B.t18 sky130_fd_pr__pfet_01v8 ad=1.45 pd=10.58 as=1.45 ps=10.58 w=5 l=0.5
X10 S0 G0 D0 B.t7 sky130_fd_pr__pfet_01v8 ad=1.45 pd=10.58 as=1.45 ps=10.58 w=5 l=0.5
X11 S13 G13 D13 B.t9 sky130_fd_pr__pfet_01v8 ad=1.45 pd=10.58 as=1.45 ps=10.58 w=5 l=0.5
X12 S11 G11 D11 B.t1 sky130_fd_pr__pfet_01v8 ad=1.45 pd=10.58 as=1.45 ps=10.58 w=5 l=0.5
X13 S9 G9 D9 B.t17 sky130_fd_pr__pfet_01v8 ad=1.45 pd=10.58 as=1.45 ps=10.58 w=5 l=0.5
X14 S18 G18 D18 B.t12 sky130_fd_pr__pfet_01v8 ad=1.45 pd=10.58 as=1.45 ps=10.58 w=5 l=0.5
X15 S4 G4 D4 B.t6 sky130_fd_pr__pfet_01v8 ad=1.45 pd=10.58 as=1.45 ps=10.58 w=5 l=0.5
X16 S2 G2 D2 B.t14 sky130_fd_pr__pfet_01v8 ad=1.45 pd=10.58 as=1.45 ps=10.58 w=5 l=0.5
X17 S1 G1 D1 B.t19 sky130_fd_pr__pfet_01v8 ad=1.45 pd=10.58 as=1.45 ps=10.58 w=5 l=0.5
X18 S15 G15 D15 B.t0 sky130_fd_pr__pfet_01v8 ad=1.45 pd=10.58 as=1.45 ps=10.58 w=5 l=0.5
X19 S7 G7 D7 B.t2 sky130_fd_pr__pfet_01v8 ad=1.45 pd=10.58 as=1.45 ps=10.58 w=5 l=0.5
R0 B.n6 B.n4 55.6541
R1 B.n6 B.n1 44414.1
R2 B.t18 B.n2 1397.87
R3 B.n2 B.n3 4280.88
R4 B.n2 B.n1 4280.88
R5 B.n4 B.n3 4275.52
R6 B.n1 B.n0 4694.59
R7 B.t7 B.t19 2386.59
R8 B.t19 B.t14 2386.59
R9 B.t14 B.t5 2386.59
R10 B.t5 B.t6 2386.59
R11 B.t6 B.t10 2386.59
R12 B.t10 B.t4 2386.59
R13 B.t4 B.t2 2386.59
R14 B.t2 B.t11 2386.59
R15 B.t11 B.t17 2386.59
R16 B.t13 B.t1 2386.59
R17 B.t1 B.t15 2386.59
R18 B.t15 B.t9 2386.59
R19 B.t9 B.t3 2386.59
R20 B.t3 B.t0 2386.59
R21 B.t0 B.t16 2386.59
R22 B.t16 B.t8 2386.59
R23 B.t8 B.t12 2386.59
R24 B.t12 B.t18 2386.59
R25 B.n6 B.t7 1347.64
R26 B.t17 B.n5 1193.29
R27 B.n5 B.t13 1193.29
R28 B B.n4 5.93733
R29 B B.n0 42.9181
R30 B.n5 B.n3 1.01978
R31 B.n5 B.n1 1.01978
C0 B D3 0.30469f
C1 G14 D14 0.1785f
C2 B D6 0.30469f
C3 B S17 0.30469f
C4 B G3 0.22141f
C5 B D19 0.30948f
C6 B S12 0.30469f
C7 S1 D1 0.24355f
C8 G9 S9 0.1785f
C9 B S2 0.30469f
C10 G7 G6 0.0552f
C11 B G18 0.22141f
C12 B S10 0.30469f
C13 G6 S6 0.1785f
C14 S13 D13 0.24355f
C15 D15 G15 0.1785f
C16 B D12 0.30469f
C17 B G8 0.22141f
C18 S5 S6 0.0053f
C19 S11 G11 0.1785f
C20 D14 S14 0.24355f
C21 B D15 0.30469f
C22 B G9 0.22141f
C23 G14 G15 0.0552f
C24 G0 S0 0.1785f
C25 D16 G16 0.1785f
C26 S1 S0 0.0053f
C27 B G1 0.22141f
C28 B G14 0.22141f
C29 G3 D3 0.1785f
C30 B S16 0.30469f
C31 D8 D9 0.0053f
C32 G10 S10 0.1785f
C33 G17 G16 0.0552f
C34 D15 S15 0.24355f
C35 G4 D4 0.1785f
C36 G13 S13 0.1785f
C37 D1 D0 0.0053f
C38 G13 D13 0.1785f
C39 D8 S8 0.24355f
C40 S11 D11 0.24355f
C41 B G11 0.22141f
C42 G7 S7 0.1785f
C43 G10 G9 0.0552f
C44 B D2 0.30469f
C45 S12 D12 0.24355f
C46 D7 D8 0.0053f
C47 G7 D7 0.1785f
C48 S16 S15 0.0053f
C49 B S14 0.30469f
C50 S7 S6 0.0053f
C51 D5 S5 0.24355f
C52 B G19 0.25255f
C53 D9 D10 0.0053f
C54 D5 D4 0.0053f
C55 G13 G12 0.0552f
C56 B S18 0.30476f
C57 D14 D13 0.0053f
C58 G0 B 0.25255f
C59 B S1 0.30476f
C60 D0 S0 0.24355f
C61 S16 S17 0.0053f
C62 B D8 0.30469f
C63 B G7 0.22141f
C64 B D11 0.30469f
C65 G10 G11 0.0552f
C66 G9 G8 0.0552f
C67 B D17 0.30469f
C68 S15 S14 0.0053f
C69 D2 D3 0.0053f
C70 B S6 0.30469f
C71 B D16 0.30469f
C72 G5 G4 0.0552f
C73 B D18 0.30476f
C74 B G2 0.22141f
C75 D2 S2 0.24355f
C76 B S13 0.30469f
C77 D19 G19 0.1785f
C78 B D10 0.30469f
C79 G5 G6 0.0552f
C80 B G17 0.22141f
C81 S18 S17 0.0053f
C82 B D13 0.30469f
C83 B G4 0.22141f
C84 B S19 0.30948f
C85 G5 S5 0.1785f
C86 B S3 0.30469f
C87 G18 G19 0.0552f
C88 D5 G5 0.1785f
C89 G18 S18 0.1785f
C90 S1 S2 0.0053f
C91 D17 S17 0.24355f
C92 B D0 0.30948f
C93 D6 S6 0.24355f
C94 B G6 0.22141f
C95 B D1 0.30476f
C96 B G12 0.22141f
C97 G16 G15 0.0552f
C98 S4 G4 0.1785f
C99 B S5 0.30469f
C100 B D5 0.30469f
C101 G14 S14 0.1785f
C102 S3 S4 0.0053f
C103 G3 G2 0.0552f
C104 D12 D11 0.0053f
C105 D18 D19 0.0053f
C106 D8 G8 0.1785f
C107 G10 D10 0.1785f
C108 B D4 0.30469f
C109 G7 G8 0.0552f
C110 B G16 0.22141f
C111 G2 S2 0.1785f
C112 G13 B 0.22141f
C113 D9 S9 0.24355f
C114 G18 D18 0.1785f
C115 G0 G1 0.0552f
C116 S7 S8 0.0053f
C117 G17 S17 0.1785f
C118 S1 G1 0.1785f
C119 S12 S13 0.0053f
C120 S3 D3 0.24355f
C121 S5 S4 0.0053f
C122 G3 G4 0.0552f
C123 S8 S9 0.0053f
C124 D7 S7 0.24355f
C125 D19 S19 0.24355f
C126 D16 D15 0.0053f
C127 S3 G3 0.1785f
C128 S4 D4 0.24355f
C129 B S0 0.30948f
C130 G18 G17 0.0552f
C131 S3 S2 0.0053f
C132 S10 D10 0.24355f
C133 B D9 0.30469f
C134 D6 G6 0.1785f
C135 B D14 0.30469f
C136 D12 D13 0.0053f
C137 G1 G2 0.0552f
C138 D16 S16 0.24355f
C139 G11 D11 0.1785f
C140 D5 D6 0.0053f
C141 G12 S12 0.1785f
C142 B S11 0.30469f
C143 D3 D4 0.0053f
C144 B S8 0.30469f
C145 B S7 0.30469f
C146 B D7 0.30469f
C147 B S9 0.30469f
C148 B G5 0.22141f
C149 G12 D12 0.1785f
C150 D2 G2 0.1785f
C151 B G15 0.22141f
C152 G1 D1 0.1785f
C153 D18 S18 0.24355f
C154 S13 S14 0.0053f
C155 S11 S12 0.0053f
C156 D16 D17 0.0053f
C157 G13 G14 0.0552f
C158 S16 G16 0.1785f
C159 D18 D17 0.0053f
C160 G15 S15 0.1785f
C161 D6 D7 0.0053f
C162 G19 S19 0.1785f
C163 D2 D1 0.0053f
C164 G12 G11 0.0552f
C165 B S4 0.30469f
C166 S18 S19 0.0053f
C167 B S15 0.30469f
C168 G9 D9 0.1785f
C169 S11 S10 0.0053f
C170 D15 D14 0.0053f
C171 D11 D10 0.0053f
C172 G17 D17 0.1785f
C173 G8 S8 0.1785f
C174 B G10 0.22141f
C175 G0 D0 0.1785f
C176 S10 S9 0.0053f
C177 S0 VSUBS 0.16022f
C178 D0 VSUBS 0.16022f
C179 S1 VSUBS 0.14068f
C180 D1 VSUBS 0.14068f
C181 S2 VSUBS 0.14068f
C182 D2 VSUBS 0.14068f
C183 S3 VSUBS 0.14068f
C184 D3 VSUBS 0.14068f
C185 S4 VSUBS 0.14068f
C186 D4 VSUBS 0.14068f
C187 S5 VSUBS 0.14068f
C188 D5 VSUBS 0.14068f
C189 S6 VSUBS 0.14068f
C190 D6 VSUBS 0.14068f
C191 S7 VSUBS 0.14068f
C192 D7 VSUBS 0.14068f
C193 S8 VSUBS 0.14068f
C194 D8 VSUBS 0.14068f
C195 S9 VSUBS 0.14068f
C196 D9 VSUBS 0.14068f
C197 S10 VSUBS 0.14068f
C198 D10 VSUBS 0.14068f
C199 S11 VSUBS 0.14068f
C200 D11 VSUBS 0.14068f
C201 S12 VSUBS 0.14068f
C202 D12 VSUBS 0.14068f
C203 S13 VSUBS 0.14068f
C204 D13 VSUBS 0.14068f
C205 S14 VSUBS 0.14068f
C206 D14 VSUBS 0.14068f
C207 S15 VSUBS 0.14068f
C208 D15 VSUBS 0.14068f
C209 S16 VSUBS 0.14068f
C210 D16 VSUBS 0.14068f
C211 S17 VSUBS 0.14068f
C212 D17 VSUBS 0.14068f
C213 S18 VSUBS 0.14068f
C214 D18 VSUBS 0.14068f
C215 S19 VSUBS 0.16022f
C216 D19 VSUBS 0.16022f
C217 B VSUBS 46.05615f
C218 B.n0 VSUBS 0.22829f
C219 B.n1 VSUBS 0.90926f
C220 B.n2 VSUBS 1.08154f
C221 B.n3 VSUBS 0.91133f
C222 B.t18 VSUBS 0.53055f
C223 B.t12 VSUBS 0.6472f
C224 B.t8 VSUBS 0.6472f
C225 B.t16 VSUBS 0.6472f
C226 B.t0 VSUBS 0.6472f
C227 B.t3 VSUBS 0.6472f
C228 B.t9 VSUBS 0.6472f
C229 B.t15 VSUBS 0.6472f
C230 B.t1 VSUBS 0.6472f
C231 B.t13 VSUBS 0.4854f
C232 B.n5 VSUBS 0.3236f
C233 B.t17 VSUBS 0.4854f
C234 B.t11 VSUBS 0.6472f
C235 B.t2 VSUBS 0.6472f
C236 B.t4 VSUBS 0.6472f
C237 B.t10 VSUBS 0.6472f
C238 B.t6 VSUBS 0.6472f
C239 B.t5 VSUBS 0.6472f
C240 B.t14 VSUBS 0.6472f
C241 B.t19 VSUBS 0.6472f
C242 B.t7 VSUBS 0.50722f
C243 B.n6 VSUBS 0.64944f
.ends

.subckt sky130_fd_pr__cap_mim_m3_1_6ZDEYE C2 C1 w_n1216_n1040#
X0 C1 C2 sky130_fd_pr__cap_mim_m3_1 l=10 w=10
C0 C2 C1 9.25061f
C1 C2 w_n1216_n1040# 4.84784f
.ends

.subckt ldo_open vdd vref vout vdd.n32 vdd.n43 vdd.n10 vdd.n21 vss.n18 vss.n29 w_2824_2788.n1
+ vdd.n20 vdd.n31 vdd.n42 vss.n17 vss.n28 vss.n39 w_2824_2788.n0 m1_81694_94112.n9
+ vdd.n30 vdd.n41 vss.n16 vss.n27 vss.n38 vss.n49 m1_81694_94112.n8 vdd.n40 vss.n15
+ vss.n26 vss.n37 vss.n48 vss.n59 m1_81694_94112.n7 vss.n14 vss.n25 vss.n36 vss.n47
+ vss.n58 vss.n69 m1_81694_94112.n6 vss.n9 vss.n13 vss.n24 vss.n35 vss.n46 vss.n57
+ vss.n68 vss.n79 m1_81694_94112.n5 vss.n8 vss.n12 vss.n23 vss.n34 vss.n45 vss.n56
+ vss.n67 vss.n78 m1_81694_94112.n4 vss.n7 vss.n55 vss.n66 vss.n77 m1_81694_94112.n3
+ vss.n11 vss.n22 vss.n33 vss.n44 vss.n6 vss.n10 vss.n21 vss.n32 vss.n43 vss.n54 vss.n65
+ vss.n76 m1_81694_94112.n2 vss.n5 vss.n20 vss.n31 vss.n42 vss.n53 vss.n64 vss.n75
+ m1_81694_94112.n1 vss.n4 vss.n30 vss.n41 vss.n52 vss.n63 vss.n74 m1_81694_94112.n0
+ vss.n3 vss.n40 vss.n51 vss.n62 vss.n73 vss.n2 vss.n50 vss.n61 vss.n72 vss.n1 vss.n60
+ vss.n71 vss.n82 w_2824_2788.n19 vss.n0 vss.n70 vss.n81 w_2824_2788.n29 w_2824_2788.n18
+ vss.n80 w_2824_2788.n39 w_2824_2788.n28 w_2824_2788.n17 vout.n9 w_2824_2788.n49
+ w_2824_2788.n38 w_2824_2788.n27 w_2824_2788.n16 vref.n0 vout.n8 w_2824_2788.n59
+ w_2824_2788.n48 w_2824_2788.n37 w_2824_2788.n26 w_2824_2788.n15 vout.n7 w_2824_2788.n69
+ w_2824_2788.n58 w_2824_2788.n47 w_2824_2788.n36 w_2824_2788.n25 w_2824_2788.n14
+ vout.n6 w_2824_2788.n68 w_2824_2788.n57 w_2824_2788.n46 w_2824_2788.n35 w_2824_2788.n24
+ w_2824_2788.n13 w_2824_2788.n79 vout.n5 w_2824_2788.n67 w_2824_2788.n56 w_2824_2788.n45
+ w_2824_2788.n34 w_2824_2788.n23 w_2824_2788.n12 w_2824_2788.n78 vout.n4 w_2824_2788.n77
+ w_2824_2788.n66 w_2824_2788.n55 w_2824_2788.n44 w_2824_2788.n33 w_2824_2788.n22
+ w_2824_2788.n11 vout.n19 vout.n3 w_2824_2788.n76 w_2824_2788.n65 w_2824_2788.n54
+ w_2824_2788.n43 w_2824_2788.n32 w_2824_2788.n21 w_2824_2788.n10 vdd.n9 vout.n18
+ vout.n2 w_2824_2788.n75 w_2824_2788.n64 w_2824_2788.n53 w_2824_2788.n42 w_2824_2788.n31
+ w_2824_2788.n20 vdd.n8 vout.n17 vout.n1 w_2824_2788.n74 w_2824_2788.n63 w_2824_2788.n52
+ w_2824_2788.n41 w_2824_2788.n30 vdd.n7 vout.n16 m1_81694_94112.n19 vout.n0 w_2824_2788.n73
+ w_2824_2788.n62 w_2824_2788.n51 w_2824_2788.n40 vdd.n6 vout.n15 m1_81694_94112.n18
+ w_2824_2788.n72 w_2824_2788.n61 w_2824_2788.n50 vdd.n5 vout.n14 m1_81694_94112.n17
+ vdd.n19 w_2824_2788.n71 w_2824_2788.n60 vdd.n4 vout.n13 m1_81694_94112.n16 vdd.n18
+ vdd.n29 w_2824_2788.n70 w_2824_2788.n9 w_2824_2788.n81 vdd.n3 vout.n12 vss m1_81694_94112.n15
+ vdd.n17 vdd.n28 vdd.n39 w_2824_2788.n8 w_2824_2788.n80 vdd.n2 vout.n11 m1_81694_94112.n14
+ vdd.n16 vdd.n27 vdd.n38 w_2824_2788.n7 vdd.n1 vout.n10 m1_81694_94112.n13 vdd.n15
+ vdd.n26 vdd.n37 w_2824_2788.n6 vdd.n0 vout.n20 m1_81694_94112.n12 vdd.n14 vdd.n25
+ vdd.n36 w_2824_2788.n5 m1_81694_94112.n11 vdd.n13 vdd.n24 vdd.n35 vdd.n46 w_2824_2788.n4
+ vdd.n12 vdd.n23 vdd.n34 vdd.n45 m1_81694_94112.n10 w_2824_2788.n3 m1_81694_94112.n20
+ vdd.n11 vdd.n22 vdd.n33 vdd.n44 vss.n19 w_2824_2788.n2 d6/D
Xd10 vss d3/G vss sky130_fd_pr__res_high_po_0p35_PAVCDF
Xd0 vss d2/G vss d2/G sky130_fd_pr__nfet_01v8_XR83G9
Xd1 vss vdd d2/G sky130_fd_pr__res_high_po_0p35_5BEF7K
Xd2 vss d4/S vss d2/G sky130_fd_pr__nfet_01v8_AFE8E4
Xd3 vss d6/G d4/S d3/G sky130_fd_pr__nfet_01v8_TPXDG7
Xd4 vss d6/D d4/S vref sky130_fd_pr__nfet_01v8_TPXDG7
Xd5 vdd d6/G vdd d6/G vss sky130_fd_pr__pfet_01v8_5KKSJS
Xd6 vdd d6/D vdd d6/G vss sky130_fd_pr__pfet_01v8_5KKSJS
Xd7 vdd vout vdd d6/D vout vdd d6/D vout vdd d6/D vout vdd d6/D vout vdd d6/D vout
+ vdd d6/D vout vdd d6/D vout vdd d6/D vout vdd d6/D vout vdd d6/D vout vdd d6/D vout
+ vdd d6/D vout vdd d6/D vout vdd d6/D vout vdd d6/D vout vdd d6/D vout vdd d6/D vout
+ vdd d6/D vout vdd d6/D vout vdd d6/D vss sky130_fd_pr__pfet_01v8_FYEDVJ
Xd9 vss vout d3/G sky130_fd_pr__res_high_po_0p35_PAVCDF
Xd8 d6/D vout vss sky130_fd_pr__cap_mim_m3_1_6ZDEYE
R0 vref vref.n0 3.4105
R1 vout.n1 vout 177.548
R2 vout.n2 vout 172.156
R3 vout.n3 vout 166.763
R4 vout.n4 vout 161.371
R5 vout.n5 vout 155.978
R6 vout.n6 vout 150.587
R7 vout.n7 vout 145.194
R8 vout.n20 vout.n19 142.177
R9 vout.n8 vout 139.802
R10 vout.n9 vout 134.409
R11 vout.n10 vout 129.017
R12 vout.n11 vout 123.624
R13 vout.n12 vout 118.231
R14 vout.n13 vout 112.838
R15 vout vout.n20 110.099
R16 vout.n14 vout 107.447
R17 vout.n15 vout 102.053
R18 vout.n16 vout 96.6615
R19 vout.n17 vout 91.269
R20 vout.n18 vout 85.8766
R21 vout.n19 vout 80.4841
R22 vout.n20 vout 69.7574
R23 vout.n1 vout.n0 11.7186
R24 vout.n2 vout.n1 11.7186
R25 vout.n3 vout.n2 11.7186
R26 vout.n4 vout.n3 11.7186
R27 vout.n5 vout.n4 11.7186
R28 vout.n6 vout.n5 11.7186
R29 vout.n7 vout.n6 11.7186
R30 vout.n8 vout.n7 11.7186
R31 vout.n9 vout.n8 11.7186
R32 vout.n10 vout.n9 11.7186
R33 vout.n11 vout.n10 11.7186
R34 vout.n12 vout.n11 11.7186
R35 vout.n13 vout.n12 11.7186
R36 vout.n14 vout.n13 11.7186
R37 vout.n15 vout.n14 11.7186
R38 vout.n16 vout.n15 11.7186
R39 vout.n17 vout.n16 11.7186
R40 vout.n18 vout.n17 11.7186
R41 vout.n19 vout.n18 11.7186
R42 vout.n0 vout 3.4105
R43 vdd.n19 vdd.n17 2795.29
R44 vdd.n22 vdd.n16 2795.29
R45 vdd.n6 vdd.n4 2795.29
R46 vdd.n9 vdd.n3 2795.29
R47 vdd.n21 vdd.n17 703.912
R48 vdd.n20 vdd.n16 703.912
R49 vdd.n8 vdd.n4 703.912
R50 vdd.n7 vdd.n3 703.912
R51 vdd.n18 vdd.n14 298.166
R52 vdd.n18 vdd.n15 298.166
R53 vdd.n23 vdd.n15 298.166
R54 vdd.n5 vdd.n1 298.166
R55 vdd.n5 vdd.n2 298.166
R56 vdd.n10 vdd.n2 298.166
R57 vdd.n27 vdd.n26 247.052
R58 vdd.n24 vdd.n23 242.447
R59 vdd.n11 vdd.n10 242.447
R60 vdd.n12 vdd.n0 151.994
R61 vdd vdd.n46 151.328
R62 vdd.n46 vdd 142.314
R63 vdd.n45 vdd 139.133
R64 vdd.n44 vdd 135.952
R65 vdd.n43 vdd 132.773
R66 vdd.n42 vdd 129.593
R67 vdd.n41 vdd 126.412
R68 vdd.n40 vdd 123.231
R69 vdd.n39 vdd 120.052
R70 vdd.n38 vdd 116.871
R71 vdd.n37 vdd 113.691
R72 vdd.n36 vdd 110.51
R73 vdd.n34 vdd 104.15
R74 vdd.n35 vdd 102.829
R75 vdd.n33 vdd 100.969
R76 vdd.n32 vdd 97.7888
R77 vdd.n31 vdd 94.6085
R78 vdd.n30 vdd 91.4281
R79 vdd.n29 vdd 88.2478
R80 vdd.n28 vdd 85.0675
R81 vdd.n26 vdd 84.9162
R82 vdd.n13 vdd 84.9162
R83 vdd.n27 vdd 84.3567
R84 vdd.n25 vdd 84.3567
R85 vdd.n12 vdd 84.3567
R86 vdd.n24 vdd.n14 45.9299
R87 vdd.n11 vdd.n1 45.9299
R88 vdd.n17 vdd.n14 37.0005
R89 vdd.n16 vdd.n15 37.0005
R90 vdd.n4 vdd.n1 37.0005
R91 vdd.n3 vdd.n2 37.0005
R92 vdd.n25 vdd.n13 23.4852
R93 vdd.n19 vdd.n18 13.2148
R94 vdd.n23 vdd.n22 13.2148
R95 vdd.n6 vdd.n5 13.2148
R96 vdd.n10 vdd.n9 13.2148
R97 vdd.n13 vdd.n12 12.9519
R98 vdd.n26 vdd.n25 12.9519
R99 vdd.n28 vdd.n27 12.7436
R100 vdd.n20 vdd.n19 9.84115
R101 vdd.n22 vdd.n21 9.84115
R102 vdd.n7 vdd.n6 9.84115
R103 vdd.n9 vdd.n8 9.84115
R104 vdd vdd.n11 9.3005
R105 vdd vdd.n24 9.3005
R106 vdd.n21 vdd.n20 6.65673
R107 vdd.n8 vdd.n7 6.65673
R108 vdd.n29 vdd.n28 5.83522
R109 vdd.n30 vdd.n29 5.83522
R110 vdd.n31 vdd.n30 5.83522
R111 vdd.n32 vdd.n31 5.83522
R112 vdd.n33 vdd.n32 5.83522
R113 vdd.n34 vdd.n33 5.83522
R114 vdd.n35 vdd.n34 5.83522
R115 vdd.n36 vdd.n35 5.83522
R116 vdd.n37 vdd.n36 5.83522
R117 vdd.n38 vdd.n37 5.83522
R118 vdd.n39 vdd.n38 5.83522
R119 vdd.n40 vdd.n39 5.83522
R120 vdd.n41 vdd.n40 5.83522
R121 vdd.n42 vdd.n41 5.83522
R122 vdd.n43 vdd.n42 5.83522
R123 vdd.n44 vdd.n43 5.83522
R124 vdd.n45 vdd.n44 5.83522
R125 vdd.n46 vdd.n45 5.83522
R126 vdd.n0 vdd 3.4105
R127 vss.n56 vss.n35 38588.8
R128 vss.n56 vss.n34 38588.8
R129 vss.n54 vss.n35 38588.8
R130 vss.n54 vss.n34 38588.8
R131 vss.n10 vss.n11 21.3694
R132 vss.n81 vss.n12 15412.4
R133 vss.n80 vss.n12 15412.4
R134 vss.n74 vss.n8 15412.4
R135 vss.n76 vss.n8 15412.4
R136 vss.n74 vss.n14 15412.4
R137 vss.n76 vss.n14 15412.4
R138 vss vss.n72 7896.88
R139 vss.n22 vss.n5 6854.44
R140 vss.n71 vss.n5 6854.44
R141 vss.n22 vss.n16 6854.44
R142 vss.n71 vss.n16 6854.44
R143 vss.n64 vss.n7 6854.44
R144 vss.n25 vss.n7 6854.44
R145 vss.n64 vss.n21 6854.44
R146 vss.n25 vss.n21 6854.44
R147 vss.n36 vss.n6 5116.21
R148 vss.n61 vss.n6 5116.21
R149 vss.n36 vss.n29 5116.21
R150 vss.n61 vss.n29 5116.21
R151 vss.n44 vss.n41 3957.38
R152 vss.n50 vss.n41 3957.38
R153 vss.n44 vss.n40 3957.38
R154 vss.n50 vss.n40 3957.38
R155 vss vss.n33 2507.29
R156 vss.n53 vss.n33 2507.29
R157 vss.n53 vss.n1 2502.89
R158 vss.n1 vss 2500.89
R159 vss vss.n11 1001.41
R160 vss.n79 vss.n11 1001.41
R161 vss.n75 vss 1001.41
R162 vss.n75 vss.n3 1001.41
R163 vss.n79 vss.n0 997.008
R164 vss.n4 vss.n3 997.008
R165 vss.n0 vss 995.013
R166 vss vss.n4 995.013
R167 vss vss.n51 648.78
R168 vss vss.n62 648.78
R169 vss.n26 vss 648.78
R170 vss vss.n77 541.063
R171 vss.n38 vss 541.063
R172 vss.n68 vss.n2 503.943
R173 vss.n70 vss 445.365
R174 vss.n18 vss.n17 445.365
R175 vss.n70 vss.n17 445.365
R176 vss.n24 vss 445.365
R177 vss.n65 vss.n20 445.365
R178 vss.n24 vss.n20 445.365
R179 vss.n69 vss.n18 389.647
R180 vss.n66 vss.n65 389.647
R181 vss.n60 vss 332.425
R182 vss.n31 vss.n30 332.425
R183 vss.n60 vss.n30 332.425
R184 vss vss.n8 292.877
R185 vss vss.n56 292.877
R186 vss vss.n81 292.877
R187 vss.n10 vss.n80 286.807
R188 vss.n80 vss.n79 292.5
R189 vss.n14 vss.n13 292.5
R190 vss.n3 vss.n14 292.5
R191 vss.n8 vss.n13 292.5
R192 vss.n55 vss.n54 292.5
R193 vss.n54 vss.n53 292.5
R194 vss.n56 vss.n55 292.5
R195 vss.n81 vss.n9 286.801
R196 vss.n49 vss.n48 257.13
R197 vss.n45 vss.n42 257.13
R198 vss.n49 vss.n42 257.13
R199 vss.n59 vss.n31 239.06
R200 vss.n47 vss.n45 163.766
R201 vss.n27 vss.n21 117.001
R202 vss.n21 vss.n20 117.001
R203 vss.n27 vss.n7 117.001
R204 vss vss.n7 117.001
R205 vss.n16 vss.n15 117.001
R206 vss.n17 vss.n16 117.001
R207 vss.n5 vss.n15 117.001
R208 vss vss.n5 117.001
R209 vss.n57 vss.n1 98.6842
R210 vss.n82 vss.n0 95.5508
R211 vss.n4 vss.n2 95.5508
R212 vss.n69 vss.n68 91.4431
R213 vss.n59 vss.n58 91.4431
R214 vss.n67 vss.n66 91.4431
R215 vss vss.n82 88.1518
R216 vss.n48 vss.n47 83.577
R217 vss vss.n59 83.2005
R218 vss.n19 vss 82.6703
R219 vss.n32 vss 82.5137
R220 vss vss.n6 73.502
R221 vss.n40 vss.n39 73.1255
R222 vss.n42 vss.n40 73.1255
R223 vss.n51 vss.n50 73.1255
R224 vss.n50 vss.n49 73.1255
R225 vss.n41 vss.n39 73.1255
R226 vss.n48 vss.n41 73.1255
R227 vss.n44 vss.n43 73.1255
R228 vss.n45 vss.n44 73.1255
R229 vss.n29 vss.n28 73.1255
R230 vss.n30 vss.n29 73.1255
R231 vss.n6 vss.n28 73.1255
R232 vss.n66 vss 45.9299
R233 vss vss.n69 45.9299
R234 vss.n62 vss.n61 41.7862
R235 vss.n61 vss.n60 41.7862
R236 vss.n37 vss.n36 41.7862
R237 vss.n36 vss.n31 41.7862
R238 vss.n68 vss.n67 36.4852
R239 vss.n58 vss.n57 36.0936
R240 vss vss 35.2034
R241 vss.n82 vss.n2 30.2102
R242 vss.n67 vss.n19 23.4852
R243 vss.n26 vss.n25 22.5005
R244 vss.n25 vss.n24 22.5005
R245 vss.n64 vss.n63 22.5005
R246 vss.n65 vss.n64 22.5005
R247 vss.n72 vss.n71 22.5005
R248 vss.n71 vss.n70 22.5005
R249 vss.n23 vss.n22 22.5005
R250 vss.n22 vss.n18 22.5005
R251 vss.n57 vss.n32 17.6019
R252 vss.n9 vss.n10 0.252336
R253 vss.n46 vss.n32 13.3686
R254 vss.n58 vss.n19 13.3686
R255 vss.n43 vss.n39 13.0929
R256 vss.n51 vss.n39 13.0929
R257 vss.n37 vss.n28 13.0929
R258 vss.n62 vss.n28 13.0929
R259 vss.n47 vss 9.3005
R260 vss.n63 vss.n27 9.27587
R261 vss.n27 vss.n26 9.27587
R262 vss.n23 vss.n15 9.27587
R263 vss.n72 vss.n15 9.27587
R264 vss.n4 vss.n74 8.7655
R265 vss.n12 vss.n0 8.7655
R266 vss.n78 vss.n12 8.1255
R267 vss.n77 vss.n76 8.1255
R268 vss.n76 vss.n75 8.1255
R269 vss.n74 vss.n73 8.1255
R270 vss.n9 vss.n78 5.90651
R271 vss.n73 vss.n13 5.6497
R272 vss.n77 vss.n13 5.6497
R273 vss.n55 vss.n52 5.6497
R274 vss.n55 vss.n38 5.6497
R275 vss.n35 vss.n1 3.71945
R276 vss vss.n46 3.4105
R277 vss.n38 vss.n34 3.07945
R278 vss.n34 vss.n33 3.07945
R279 vss.n52 vss.n35 3.07945
R280 vss.n73 vss 2.02352
R281 vss.n78 vss 2.02352
R282 vss.n43 vss 2.02352
R283 vss.n52 vss 2.02352
R284 vss vss.n37 2.02352
R285 vss.n63 vss 2.02352
R286 vss vss.n23 2.02352
R287 vss vss 1.89187
R288 d6/D m1_81694_94112.n20 227.798
R289 m1_81694_94112.n1 d6/D 174.571
R290 m1_81694_94112.n2 d6/D 169.178
R291 m1_81694_94112.n3 d6/D 163.786
R292 m1_81694_94112.n4 d6/D 158.393
R293 m1_81694_94112.n5 d6/D 153
R294 m1_81694_94112.n6 d6/D 147.607
R295 m1_81694_94112.n0 d6/D 142.643
R296 m1_81694_94112.n7 d6/D 142.215
R297 m1_81694_94112.n8 d6/D 136.822
R298 m1_81694_94112.n9 d6/D 131.43
R299 m1_81694_94112.n10 d6/D 126.037
R300 m1_81694_94112.n11 d6/D 120.645
R301 m1_81694_94112.n12 d6/D 115.252
R302 m1_81694_94112.n13 d6/D 109.861
R303 m1_81694_94112.n14 d6/D 104.469
R304 m1_81694_94112.n15 d6/D 99.0756
R305 m1_81694_94112.n16 d6/D 93.6831
R306 m1_81694_94112.n17 d6/D 88.2906
R307 m1_81694_94112.n18 d6/D 82.8982
R308 m1_81694_94112.n19 d6/D 77.5057
R309 m1_81694_94112.n20 d6/D 72.1132
R310 m1_81694_94112.n0 d6/D 69.3183
R311 m1_81694_94112.n1 m1_81694_94112.n0 30.6019
R312 m1_81694_94112.n2 m1_81694_94112.n1 11.7186
R313 m1_81694_94112.n3 m1_81694_94112.n2 11.7186
R314 m1_81694_94112.n4 m1_81694_94112.n3 11.7186
R315 m1_81694_94112.n5 m1_81694_94112.n4 11.7186
R316 m1_81694_94112.n6 m1_81694_94112.n5 11.7186
R317 m1_81694_94112.n7 m1_81694_94112.n6 11.7186
R318 m1_81694_94112.n8 m1_81694_94112.n7 11.7186
R319 m1_81694_94112.n9 m1_81694_94112.n8 11.7186
R320 m1_81694_94112.n10 m1_81694_94112.n9 11.7186
R321 m1_81694_94112.n11 m1_81694_94112.n10 11.7186
R322 m1_81694_94112.n12 m1_81694_94112.n11 11.7186
R323 m1_81694_94112.n13 m1_81694_94112.n12 11.7186
R324 m1_81694_94112.n14 m1_81694_94112.n13 11.7186
R325 m1_81694_94112.n15 m1_81694_94112.n14 11.7186
R326 m1_81694_94112.n16 m1_81694_94112.n15 11.7186
R327 m1_81694_94112.n17 m1_81694_94112.n16 11.7186
R328 m1_81694_94112.n18 m1_81694_94112.n17 11.7186
R329 m1_81694_94112.n19 m1_81694_94112.n18 11.7186
R330 m1_81694_94112.n20 m1_81694_94112.n19 11.7186
R331 d6/D d6/D 9.30224
R332 d6/D d6/D 9.30224
R333 d6/D d6/D 9.30224
R334 d6/D d6/D 9.30224
R335 d6/D d6/D 9.30224
R336 d6/D d6/D 9.30224
R337 d6/D d6/D 9.30224
R338 d6/D d6/D 9.30224
R339 d6/D d6/D 9.30224
R340 d6/D d6/D 9.30224
R341 d6/D d6/D 9.30224
R342 d6/D d6/D 9.30224
R343 d6/D d6/D 9.30224
R344 d6/D d6/D 9.30224
R345 d6/D d6/D 9.30224
R346 d6/D d6/D 9.30224
R347 d6/D d6/D 9.30224
R348 d6/D d6/D 9.30224
R349 d6/D d6/D 9.30224
R350 d6/D d6/D 9.30224
R351 w_2824_2788.n74 w_2824_2788.n18 38588.8
R352 w_2824_2788.n74 w_2824_2788.n17 38588.8
R353 w_2824_2788.n72 w_2824_2788.n18 38588.8
R354 w_2824_2788.n72 w_2824_2788.n17 38588.8
R355 w_2824_2788.n38 w_2824_2788.n34 15412.4
R356 w_2824_2788.n36 w_2824_2788.n6 21.3694
R357 w_2824_2788.n38 w_2824_2788.n4 15412.4
R358 w_2824_2788.n43 w_2824_2788.n32 15412.4
R359 w_2824_2788.n41 w_2824_2788.n32 15412.4
R360 w_2824_2788.n43 w_2824_2788.n31 15412.4
R361 w_2824_2788.n41 w_2824_2788.n31 15412.4
R362 w_2824_2788.n47 vss 7896.88
R363 w_2824_2788.n53 w_2824_2788.n29 6854.44
R364 w_2824_2788.n46 w_2824_2788.n29 6854.44
R365 w_2824_2788.n53 w_2824_2788.n28 6854.44
R366 w_2824_2788.n46 w_2824_2788.n28 6854.44
R367 w_2824_2788.n61 w_2824_2788.n25 6854.44
R368 w_2824_2788.n50 w_2824_2788.n25 6854.44
R369 w_2824_2788.n61 w_2824_2788.n24 6854.44
R370 w_2824_2788.n50 w_2824_2788.n24 6854.44
R371 w_2824_2788.n68 w_2824_2788.n21 5116.21
R372 w_2824_2788.n64 w_2824_2788.n21 5116.21
R373 w_2824_2788.n68 w_2824_2788.n20 5116.21
R374 w_2824_2788.n64 w_2824_2788.n20 5116.21
R375 w_2824_2788.n13 w_2824_2788.n10 3957.38
R376 w_2824_2788.n80 w_2824_2788.n10 3957.38
R377 w_2824_2788.n13 w_2824_2788.n9 3957.38
R378 w_2824_2788.n80 w_2824_2788.n9 3957.38
R379 vss w_2824_2788.n16 2507.29
R380 w_2824_2788.n71 w_2824_2788.n16 2507.29
R381 w_2824_2788.n71 w_2824_2788.n1 2502.89
R382 w_2824_2788.n1 vss 2501.27
R383 vss w_2824_2788.n36 1001.41
R384 w_2824_2788.n36 w_2824_2788.n35 1001.41
R385 vss w_2824_2788.n42 1001.41
R386 w_2824_2788.n42 w_2824_2788.n33 1001.41
R387 w_2824_2788.n0 w_2824_2788.n35 997.008
R388 w_2824_2788.n3 w_2824_2788.n33 997.008
R389 w_2824_2788.n0 vss 995.389
R390 w_2824_2788.n3 vss 995.389
R391 vss w_2824_2788.n81 648.78
R392 w_2824_2788.n63 vss 648.78
R393 vss w_2824_2788.n51 648.78
R394 w_2824_2788.n70 vss 541.063
R395 w_2824_2788.n40 vss 541.063
R396 w_2824_2788.n56 w_2824_2788.n2 503.943
R397 w_2824_2788.n49 vss 445.365
R398 w_2824_2788.n49 w_2824_2788.n26 445.365
R399 w_2824_2788.n60 w_2824_2788.n26 445.365
R400 w_2824_2788.n45 vss 445.365
R401 w_2824_2788.n45 w_2824_2788.n27 445.365
R402 w_2824_2788.n54 w_2824_2788.n27 445.365
R403 w_2824_2788.n60 w_2824_2788.n59 389.647
R404 w_2824_2788.n55 w_2824_2788.n54 389.647
R405 vss w_2824_2788.n65 332.425
R406 w_2824_2788.n65 w_2824_2788.n22 332.425
R407 w_2824_2788.n67 w_2824_2788.n22 332.425
R408 w_2824_2788.n73 w_2824_2788.n72 292.5
R409 w_2824_2788.n72 w_2824_2788.n71 292.5
R410 w_2824_2788.n74 w_2824_2788.n73 292.5
R411 vss w_2824_2788.n74 292.5
R412 w_2824_2788.n31 w_2824_2788.n30 292.5
R413 w_2824_2788.n33 w_2824_2788.n31 292.5
R414 w_2824_2788.n32 w_2824_2788.n30 292.5
R415 vss w_2824_2788.n32 292.5
R416 w_2824_2788.n35 w_2824_2788.n4 292.5
R417 w_2824_2788.n34 w_2824_2788.n6 286.807
R418 vss w_2824_2788.n34 292.5
R419 w_2824_2788.n5 w_2824_2788.n4 286.801
R420 w_2824_2788.n79 w_2824_2788.n78 257.13
R421 w_2824_2788.n79 w_2824_2788.n11 257.13
R422 w_2824_2788.n14 w_2824_2788.n11 257.13
R423 w_2824_2788.n67 w_2824_2788.n66 239.06
R424 w_2824_2788.n77 w_2824_2788.n14 163.766
R425 w_2824_2788.n24 w_2824_2788.n23 117.001
R426 w_2824_2788.n26 w_2824_2788.n24 117.001
R427 w_2824_2788.n25 w_2824_2788.n23 117.001
R428 vss w_2824_2788.n25 117.001
R429 w_2824_2788.n48 w_2824_2788.n28 117.001
R430 w_2824_2788.n28 w_2824_2788.n27 117.001
R431 w_2824_2788.n48 w_2824_2788.n29 117.001
R432 w_2824_2788.n29 vss 117.001
R433 w_2824_2788.n75 w_2824_2788.n1 98.6842
R434 w_2824_2788.n0 w_2824_2788.n37 95.5508
R435 w_2824_2788.n3 w_2824_2788.n2 95.5508
R436 w_2824_2788.n66 w_2824_2788.n15 91.4431
R437 w_2824_2788.n59 w_2824_2788.n58 91.4431
R438 w_2824_2788.n56 w_2824_2788.n55 91.4431
R439 w_2824_2788.n37 vss 88.1518
R440 w_2824_2788.n78 w_2824_2788.n77 83.577
R441 w_2824_2788.n66 vss 83.577
R442 w_2824_2788.n57 vss 82.6703
R443 w_2824_2788.n76 vss 82.5137
R444 w_2824_2788.n9 w_2824_2788.n8 73.1255
R445 w_2824_2788.n11 w_2824_2788.n9 73.1255
R446 w_2824_2788.n81 w_2824_2788.n80 73.1255
R447 w_2824_2788.n80 w_2824_2788.n79 73.1255
R448 w_2824_2788.n10 w_2824_2788.n8 73.1255
R449 w_2824_2788.n78 w_2824_2788.n10 73.1255
R450 w_2824_2788.n13 w_2824_2788.n12 73.1255
R451 w_2824_2788.n14 w_2824_2788.n13 73.1255
R452 w_2824_2788.n20 w_2824_2788.n19 73.1255
R453 w_2824_2788.n22 w_2824_2788.n20 73.1255
R454 w_2824_2788.n21 w_2824_2788.n19 73.1255
R455 vss w_2824_2788.n21 73.1255
R456 w_2824_2788.n59 vss 45.9299
R457 w_2824_2788.n55 vss 45.9299
R458 w_2824_2788.n64 w_2824_2788.n63 41.7862
R459 w_2824_2788.n65 w_2824_2788.n64 41.7862
R460 w_2824_2788.n69 w_2824_2788.n68 41.7862
R461 w_2824_2788.n68 w_2824_2788.n67 41.7862
R462 w_2824_2788.n58 w_2824_2788.n56 36.4852
R463 w_2824_2788.n75 w_2824_2788.n15 36.0936
R464 vss vss 35.0205
R465 w_2824_2788.n37 w_2824_2788.n2 30.2102
R466 w_2824_2788.n58 w_2824_2788.n57 23.4852
R467 w_2824_2788.n51 w_2824_2788.n50 22.5005
R468 w_2824_2788.n50 w_2824_2788.n49 22.5005
R469 w_2824_2788.n62 w_2824_2788.n61 22.5005
R470 w_2824_2788.n61 w_2824_2788.n60 22.5005
R471 w_2824_2788.n47 w_2824_2788.n46 22.5005
R472 w_2824_2788.n46 w_2824_2788.n45 22.5005
R473 w_2824_2788.n53 w_2824_2788.n52 22.5005
R474 w_2824_2788.n54 w_2824_2788.n53 22.5005
R475 w_2824_2788.n76 w_2824_2788.n75 17.6019
R476 vss w_2824_2788.n76 16.7786
R477 w_2824_2788.n6 w_2824_2788.n5 0.252336
R478 w_2824_2788.n57 w_2824_2788.n15 13.3686
R479 w_2824_2788.n12 w_2824_2788.n8 13.0929
R480 w_2824_2788.n81 w_2824_2788.n8 13.0929
R481 w_2824_2788.n69 w_2824_2788.n19 13.0929
R482 w_2824_2788.n63 w_2824_2788.n19 13.0929
R483 w_2824_2788.n77 vss 9.3005
R484 w_2824_2788.n62 w_2824_2788.n23 9.27587
R485 w_2824_2788.n51 w_2824_2788.n23 9.27587
R486 w_2824_2788.n52 w_2824_2788.n48 9.27587
R487 w_2824_2788.n48 w_2824_2788.n47 9.27587
R488 w_2824_2788.n43 w_2824_2788.n3 8.7655
R489 w_2824_2788.n38 w_2824_2788.n0 8.7655
R490 w_2824_2788.n41 w_2824_2788.n40 8.1255
R491 w_2824_2788.n42 w_2824_2788.n41 8.1255
R492 w_2824_2788.n44 w_2824_2788.n43 8.1255
R493 w_2824_2788.n39 w_2824_2788.n38 8.1255
R494 w_2824_2788.n39 w_2824_2788.n5 5.90651
R495 w_2824_2788.n73 w_2824_2788.n7 5.6497
R496 w_2824_2788.n73 w_2824_2788.n70 5.6497
R497 w_2824_2788.n44 w_2824_2788.n30 5.6497
R498 w_2824_2788.n40 w_2824_2788.n30 5.6497
R499 w_2824_2788.n18 w_2824_2788.n1 3.71945
R500 w_2824_2788.n70 w_2824_2788.n17 3.07945
R501 w_2824_2788.n17 w_2824_2788.n16 3.07945
R502 w_2824_2788.n18 w_2824_2788.n7 3.07945
R503 w_2824_2788.n12 vss 2.02352
R504 vss w_2824_2788.n7 2.02352
R505 vss w_2824_2788.n69 2.02352
R506 vss w_2824_2788.n62 2.02352
R507 w_2824_2788.n52 vss 2.02352
R508 vss w_2824_2788.n44 2.02352
R509 vss w_2824_2788.n39 2.02352
R510 vss vss 1.8605
C0 vout d6/D 0.13907p
C1 d6/G d3/G 0.60583f
C2 d6/G d6/D 0.71998f
C3 vout vdd 4.22081f
C4 d6/G d4/S 0.17639f
C5 d6/G vdd 0.68996f
C6 d6/G vref 0.07316f
C7 d3/G d4/S 0.20542f
C8 vdd d3/G 1.82908f
C9 d6/D d4/S 0.10323f
C10 vdd d6/D 4.95826f
C11 d3/G vref 0.07316f
C12 d2/G d4/S 0.55857f
C13 vref d6/D 0.3519f
C14 vdd d2/G 0.07316f
C15 vout d3/G 1.60959f
C16 vref d4/S 0.13226f
C17 w_2824_2788.n0 vss 0.00294f
C18 w_2824_2788.n1 vss 0.00322f
C19 w_2824_2788.n2 vss 0.01255f
C20 w_2824_2788.n3 vss 0.00294f
C21 w_2824_2788.n4 vss 0
C22 w_2824_2788.n5 vss 0.02933f
C23 w_2824_2788.n6 vss 0.00264f
C24 w_2824_2788.n7 vss 0.01322f
C25 w_2824_2788.n8 vss 0.04513f
C26 w_2824_2788.n9 vss 0
C27 w_2824_2788.n10 vss 0
C28 w_2824_2788.n11 vss 0
C29 w_2824_2788.n12 vss 0.02605f
C30 w_2824_2788.n13 vss 0
C31 w_2824_2788.n14 vss 0
C32 w_2824_2788.n15 vss 0.00439f
C33 w_2824_2788.n16 vss 0
C34 w_2824_2788.n17 vss 0
C35 w_2824_2788.n18 vss 0
C36 w_2824_2788.n19 vss 0.04513f
C37 w_2824_2788.n20 vss 0
C38 w_2824_2788.n21 vss 0
C39 w_2824_2788.n22 vss 0
C40 w_2824_2788.n23 vss 0.03197f
C41 w_2824_2788.n24 vss 0
C42 w_2824_2788.n25 vss 0
C43 w_2824_2788.n26 vss 0
C44 w_2824_2788.n27 vss 0
C45 w_2824_2788.n28 vss 0
C46 w_2824_2788.n29 vss 0
C47 w_2824_2788.n30 vss 0.01947f
C48 w_2824_2788.n31 vss 0
C49 w_2824_2788.n32 vss 0
C50 w_2824_2788.n33 vss 0
C51 w_2824_2788.n34 vss 0
C52 w_2824_2788.n35 vss 0
C53 w_2824_2788.n36 vss 0.00441f
C54 w_2824_2788.n37 vss 0.0077f
C55 w_2824_2788.n38 vss 0
C56 w_2824_2788.n39 vss 0.01322f
C57 w_2824_2788.n40 vss 0.94218f
C58 w_2824_2788.n41 vss 0
C59 w_2824_2788.n42 vss 0
C60 w_2824_2788.n43 vss 0
C61 w_2824_2788.n44 vss 0.01322f
C62 w_2824_2788.n45 vss 0
C63 w_2824_2788.n46 vss 0
C64 w_2824_2788.n47 vss 5.18098f
C65 w_2824_2788.n48 vss 0.03197f
C66 w_2824_2788.n49 vss 0
C67 w_2824_2788.n50 vss 0
C68 w_2824_2788.n51 vss 1.13406f
C69 w_2824_2788.n52 vss 0.01947f
C70 w_2824_2788.n53 vss 0
C71 w_2824_2788.n54 vss 0
C72 w_2824_2788.n55 vss 0.00268f
C73 w_2824_2788.n56 vss 0.01246f
C74 w_2824_2788.n57 vss 0.00391f
C75 w_2824_2788.n58 vss 0.00457f
C76 w_2824_2788.n59 vss 0.00268f
C77 w_2824_2788.n60 vss 0
C78 w_2824_2788.n61 vss 0
C79 w_2824_2788.n62 vss 0.01947f
C80 w_2824_2788.n63 vss 1.14064f
C81 w_2824_2788.n64 vss 0
C82 w_2824_2788.n65 vss 0
C83 w_2824_2788.n66 vss 0.00268f
C84 w_2824_2788.n67 vss 0
C85 w_2824_2788.n68 vss 0
C86 w_2824_2788.n69 vss 0.02605f
C87 w_2824_2788.n70 vss 0.94218f
C88 w_2824_2788.n71 vss 0
C89 w_2824_2788.n72 vss 0
C90 w_2824_2788.n73 vss 0.01947f
C91 w_2824_2788.n74 vss 0
C92 w_2824_2788.n75 vss 0.00479f
C93 w_2824_2788.n76 vss 0.00389f
C94 w_2824_2788.n77 vss 0
C95 w_2824_2788.n78 vss 0
C96 w_2824_2788.n79 vss 0
C97 w_2824_2788.n80 vss 0
C98 w_2824_2788.n81 vss 1.14064f
C99 m1_81694_94112.n0 vss 3.81946f
C100 m1_81694_94112.n1 vss 4.77052f
C101 m1_81694_94112.n2 vss 4.4459f
C102 m1_81694_94112.n3 vss 4.30562f
C103 m1_81694_94112.n4 vss 4.16533f
C104 m1_81694_94112.n5 vss 4.02501f
C105 m1_81694_94112.n6 vss 3.88468f
C106 m1_81694_94112.n7 vss 3.74432f
C107 m1_81694_94112.n8 vss 3.60393f
C108 m1_81694_94112.n9 vss 3.46352f
C109 m1_81694_94112.n10 vss 3.32306f
C110 m1_81694_94112.n11 vss 3.18257f
C111 m1_81694_94112.n12 vss 3.04204f
C112 m1_81694_94112.n13 vss 2.90145f
C113 m1_81694_94112.n14 vss 2.76081f
C114 m1_81694_94112.n15 vss 2.6201f
C115 m1_81694_94112.n16 vss 2.47931f
C116 m1_81694_94112.n17 vss 2.33842f
C117 m1_81694_94112.n18 vss 2.19742f
C118 m1_81694_94112.n19 vss 2.05629f
C119 m1_81694_94112.n20 vss 4.28936f
C120 vss.n0 vss 0
C121 vss.n1 vss 0
C122 vss.n2 vss 0.00308f
C123 vss.n3 vss 0
C124 vss.n4 vss 0
C125 vss.n5 vss 0
C126 vss.n6 vss 0
C127 vss.n7 vss 0
C128 vss.n8 vss 0
C129 vss.n9 vss 0.0072f
C130 vss.n10 vss 0
C131 vss.n11 vss 0.00108f
C132 vss.n12 vss 0
C133 vss.n13 vss 0.00478f
C134 vss.n14 vss 0
C135 vss.n15 vss 0.00785f
C136 vss.n16 vss 0
C137 vss.n17 vss 0
C138 vss.n18 vss 0
C139 vss.n19 vss 0
C140 vss.n20 vss 0
C141 vss.n21 vss 0
C142 vss.n22 vss 0
C143 vss.n23 vss 0.00478f
C144 vss.n24 vss 0
C145 vss.n25 vss 0
C146 vss.n26 vss 0.27846f
C147 vss.n27 vss 0.00785f
C148 vss.n28 vss 0.01108f
C149 vss.n29 vss 0
C150 vss.n30 vss 0
C151 vss.n31 vss 0
C152 vss.n32 vss 0
C153 vss.n33 vss 0
C154 vss.n34 vss 0
C155 vss.n35 vss 0
C156 vss.n36 vss 0
C157 vss.n37 vss 0.0064f
C158 vss.n38 vss 0.23135f
C159 vss.n39 vss 0.01108f
C160 vss.n40 vss 0
C161 vss.n41 vss 0
C162 vss.n42 vss 0
C163 vss.n43 vss 0.0064f
C164 vss.n44 vss 0
C165 vss.n45 vss 0
C166 vss.n46 vss 0
C167 vss.n47 vss 0
C168 vss.n48 vss 0
C169 vss.n49 vss 0
C170 vss.n50 vss 0
C171 vss.n51 vss 0.28008f
C172 vss.n52 vss 0.00325f
C173 vss.n53 vss 0
C174 vss.n54 vss 0
C175 vss.n55 vss 0.00478f
C176 vss.n56 vss 0
C177 vss.n57 vss 0.00118f
C178 vss.n58 vss 0.00108f
C179 vss.n59 vss 0
C180 vss.n60 vss 0
C181 vss.n61 vss 0
C182 vss.n62 vss 0.28008f
C183 vss.n63 vss 0.00478f
C184 vss.n64 vss 0
C185 vss.n65 vss 0
C186 vss.n66 vss 0
C187 vss.n67 vss 0.00112f
C188 vss.n68 vss 0.00306f
C189 vss.n69 vss 0
C190 vss.n70 vss 0
C191 vss.n71 vss 0
C192 vss.n72 vss 1.27216f
C193 vss.n73 vss 0.00325f
C194 vss.n74 vss 0
C195 vss.n75 vss 0
C196 vss.n76 vss 0
C197 vss.n77 vss 0.23135f
C198 vss.n78 vss 0.00325f
C199 vss.n79 vss 0
C200 vss.n80 vss 0
C201 vss.n81 vss 0
C202 vss.n82 vss 0.00189f
C203 vdd.n0 vss 0.09111f
C204 vdd.n1 vss 0
C205 vdd.n2 vss 0.00107f
C206 vdd.n3 vss 0.00845f
C207 vdd.n4 vss 0.00845f
C208 vdd.n5 vss 0.00105f
C209 vdd.n6 vss 0.00105f
C210 vdd.n7 vss 0.00677f
C211 vdd.n8 vss 0.00677f
C212 vdd.n9 vss 0.00105f
C213 vdd.n10 vss 0
C214 vdd.n11 vss 0
C215 vdd.n12 vss 0.20591f
C216 vdd.n13 vss 0.13531f
C217 vdd.n14 vss 0
C218 vdd.n15 vss 0.00107f
C219 vdd.n16 vss 0.00845f
C220 vdd.n17 vss 0.00845f
C221 vdd.n18 vss 0.00105f
C222 vdd.n19 vss 0.00105f
C223 vdd.n20 vss 0.00677f
C224 vdd.n21 vss 0.00677f
C225 vdd.n22 vss 0.00105f
C226 vdd.n23 vss 0
C227 vdd.n24 vss 0
C228 vdd.n25 vss 0.13448f
C229 vdd.n26 vss 0.25957f
C230 vdd.n27 vss 0.25862f
C231 vdd.n28 vss 0.12562f
C232 vdd.n29 vss 0.12652f
C233 vdd.n30 vss 0.13125f
C234 vdd.n31 vss 0.13598f
C235 vdd.n32 vss 0.1407f
C236 vdd.n33 vss 0.14543f
C237 vdd.n34 vss 0.15015f
C238 vdd.n35 vss 0.14889f
C239 vdd.n36 vss 0.15959f
C240 vdd.n37 vss 0.16432f
C241 vdd.n38 vss 0.16904f
C242 vdd.n39 vss 0.17375f
C243 vdd.n40 vss 0.17847f
C244 vdd.n41 vss 0.18319f
C245 vdd.n42 vss 0.1879f
C246 vdd.n43 vss 0.19262f
C247 vdd.n44 vss 0.19733f
C248 vdd.n45 vss 0.20204f
C249 vdd.n46 vss 0.41322f
C250 vout.n0 vss 0.22312f
C251 vout.n1 vss 4.50642f
C252 vout.n2 vss 4.37089f
C253 vout.n3 vss 4.23534f
C254 vout.n4 vss 4.09978f
C255 vout.n5 vss 3.9642f
C256 vout.n6 vss 3.8286f
C257 vout.n7 vss 3.69297f
C258 vout.n8 vss 3.55733f
C259 vout.n9 vss 3.42165f
C260 vout.n10 vss 3.28594f
C261 vout.n11 vss 3.1502f
C262 vout.n12 vss 3.01442f
C263 vout.n13 vss 2.87859f
C264 vout.n14 vss 2.74271f
C265 vout.n15 vss 2.60676f
C266 vout.n16 vss 2.47075f
C267 vout.n17 vss 2.33465f
C268 vout.n18 vss 2.19845f
C269 vout.n19 vss 3.29289f
C270 vout.n20 vss 4.88877f
C271 vref.n0 vss 0.02677f
C272 d3/G vss 0.21668p
C273 vout vss 1.25576p
C274 d6/D vss 1.19359p
C275 d6/G vss 0.15883p
C276 vdd vss 1.42611p
C277 vref vss 43.07956f
C278 d4/S vss 0.12382p
C279 d2/G vss 0.16091p
.ends
