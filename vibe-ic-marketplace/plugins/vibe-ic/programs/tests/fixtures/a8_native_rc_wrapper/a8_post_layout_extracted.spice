* NGSPICE file created from ldo_open.ext - technology: sky130A

.subckt sky130_fd_pr__res_high_po_0p35_PAVCDF B R1 R2
X0 R1.t0 R2.t0 B.t0 sky130_fd_pr__res_high_po_0p35 l=20
R0 R2 R2.t0 33.0976
R1 R2.t0 R2 1.933
R2 R1 R1.t0 33.0976
R3 R1.t0 R1.n0 2.10836
R4 B.n8 B.n3 15412.4
R5 B.n8 B.n2 15412.4
R6 B.n6 B.n3 15412.4
R7 B B.n1 1001.41
R8 B B.n0 1001.41
R9 B.n5 B.n1 1001.41
R10 B.n5 B.n0 1001.41
R11 B.n6 B.n5 292.5
R12 B.n8 B.t0 292.5
R13 B B.n8 292.5
R14 B.n7 B.n6 284.62
R15 B.n7 B.n2 130.613
R16 B.t0 B.n4 126.105
R17 B.n4 B 45.1593
R18 B.n2 B.n0 8.1255
R19 B.n4 B.n3 8.1255
R20 B.n3 B.n1 8.1255
R21 B.t0 B.n7 2.4798
C0 R2 B 0.46621f
C1 R1 B 0.46621f
.ends

.subckt sky130_fd_pr__nfet_01v8_XR83G9 B D S G
X0 S G D B.t0 sky130_fd_pr__nfet_01v8 ad=0.58 pd=4.58 as=0.58 ps=4.58 w=2 l=2
R0 B.n8 B.n3 3957.38
R1 B.n8 B.n2 3957.38
R2 B.n6 B.n3 3957.38
R3 B.t0 B.n4 1840.49
R4 B.n7 B.n2 1274.02
R5 B.n4 B 284.39
R6 B B.n1 257.13
R7 B B.n0 257.13
R8 B.n5 B.n1 257.13
R9 B.n5 B.n0 257.13
R10 B.n6 B.n5 73.1255
R11 B.n2 B.n0 73.1255
R12 B.n8 B.t0 73.1255
R13 B B.n8 73.1255
R14 B.n4 B.n3 73.1255
R15 B.n3 B.n1 73.1255
R16 B.n7 B.n6 48.685
R17 B.t0 B.n7 23.5424
C0 S G 0.14334f
C1 D G 0.14334f
C2 D S 0.03275f
C3 S B 0.71494f
C4 D B 0.71494f
.ends

.subckt sky130_fd_pr__res_high_po_0p35_5BEF7K B R1 R2
X0 R1.t0 R2.t0 B.t0 sky130_fd_pr__res_high_po_0p35 l=60
R0 R2 R2.t0 33.0976
R1 R2.t0 R2 1.933
R2 R1 R1.t0 33.0976
R3 R1.t0 R1.n0 2.10836
R4 B.n7 B.n3 38588.8
R5 B.n0 B.n1 54.701
R6 B.n6 B.n3 38588.8
R7 B B.n2 2507.29
R8 B B.n1 2507.29
R9 B.n5 B.n2 2507.29
R10 B.n5 B.n1 2507.29
R11 B.n6 B.n5 292.5
R12 B.n7 B.n0 289.913
R13 B B.n7 292.5
R14 B.t0 B.n6 289.909
R15 B.t0 B.n0 0.392283
R16 B.t0 B.n4 49.864
R17 B.n4 B 17.7155
R18 B.n4 B.n3 3.07945
R19 B.n3 B.n2 3.07945
C0 R2 B 0.46621f
C1 R1 B 0.46621f
.ends

.subckt sky130_fd_pr__nfet_01v8_AFE8E4 B D S G
X0 S G D B.t0 sky130_fd_pr__nfet_01v8 ad=1.16 pd=8.58 as=1.16 ps=8.58 w=4 l=2
R0 B.n8 B.n3 5116.21
R1 B.n8 B.n2 5116.21
R2 B.n6 B.n3 5116.21
R3 B.t0 B.n4 1237.05
R4 B.n7 B.n2 1011.54
R5 B B.n1 332.425
R6 B B.n0 332.425
R7 B.n5 B.n1 332.425
R8 B.n5 B.n0 332.425
R9 B.n4 B 191.149
R10 B.n6 B.n5 73.1255
R11 B.n8 B.t0 73.1255
R12 B B.n8 73.1255
R13 B.n7 B.n6 57.8416
R14 B.n2 B.n0 41.7862
R15 B.n4 B.n3 41.7862
R16 B.n3 B.n1 41.7862
R17 B.t0 B.n7 14.4587
C0 S G 0.2849f
C1 D G 0.2849f
C2 D S 0.06528f
C3 S B 0.9177f
C4 D B 0.9177f
.ends

.subckt sky130_fd_pr__nfet_01v8_TPXDG7 B D S G
X0 S G D B.t0 sky130_fd_pr__nfet_01v8 ad=2.32 pd=16.58 as=2.32 ps=16.58 w=8 l=1
R0 B.n8 B.n3 6854.44
R1 B.n8 B.n2 6854.44
R2 B.n6 B.n3 6854.44
R3 B.t0 B.n4 529.308
R4 B.n7 B.n2 502.753
R5 B B.n1 445.365
R6 B B.n0 445.365
R7 B.n5 B.n1 445.365
R8 B.n5 B.n0 445.365
R9 B.n6 B.n5 117.001
R10 B.n8 B.t0 117.001
R11 B B.n8 117.001
R12 B.n4 B 115.447
R13 B.n7 B.n6 106.6
R14 B.n2 B.n0 22.5005
R15 B.n4 B.n3 22.5005
R16 B.n3 B.n1 22.5005
R17 B.t0 B.n7 8.58259
C0 G S 0.43491f
C1 G D 0.43491f
C2 D S 0.23712f
C3 S B 1.03102f
C4 D B 1.03102f
.ends

.subckt sky130_fd_pr__pfet_01v8_5KKSJS B D S G VSUBS
X0 S G D B.t0 sky130_fd_pr__pfet_01v8 ad=1.16 pd=8.58 as=1.16 ps=8.58 w=4 l=1
R0 B.n5 B.n3 2795.29
R1 B.n8 B.n2 2795.29
R2 B B.n0 298.166
R3 B B.n1 298.166
R4 B.n4 B.n1 298.166
R5 B.n4 B.n0 298.166
R6 B.n7 B.n3 184.097
R7 B.n6 B.n2 184.097
R8 B B.n8 37.0005
R9 B.n5 B.n4 37.0005
R10 B.n8 B.n7 34.1127
R11 B.n6 B.n5 34.1127
R12 B.n3 B.n1 13.2148
R13 B.n2 B.n0 13.2148
R14 B.t0 B.n6 2.4378
R15 B.n7 B.t0 2.4378
C0 D G 0.21821f
C1 S D 0.11876f
C2 S G 0.21821f
C3 D B 0.2819f
C4 B G 0.45998f
C5 S B 0.2819f
C6 S VSUBS 0.17052f
C7 D VSUBS 0.17052f
C8 B VSUBS 2.82203f
C9 B.n0 VSUBS 0.02931f
C10 B.n1 VSUBS 0.02931f
C11 B.n2 VSUBS 0.24604f
C12 B.n3 VSUBS 0.24604f
C13 B.n4 VSUBS 0.02979f
C14 B.n5 VSUBS 0.02979f
C15 B.t0 VSUBS 0.35392f
C16 B.n8 VSUBS 0.02979f
.ends

.subckt sky130_fd_pr__pfet_01v8_FYEDVJ B D0 S0 G0 D1 S1 G1 D2 S2 G2 D3 S3 G3 D4 S4
+ G4 D5 S5 G5 D6 S6 G6 D7 S7 G7 D8 S8 G8 D9 S9 G9 D10 S10 G10 D11 S11 G11 D12 S12
+ G12 D13 S13 G13 D14 S14 G14 D15 S15 G15 D16 S16 G16 D17 S17 G17 D18 S18 G18 D19
+ S19 G19 VSUBS
X0 S17 G17 D17 B.t2 sky130_fd_pr__pfet_01v8 ad=1.45 pd=10.58 as=1.45 ps=10.58 w=5 l=0.5
X1 S5 G5 D5 B.t13 sky130_fd_pr__pfet_01v8 ad=1.45 pd=10.58 as=1.45 ps=10.58 w=5 l=0.5
X2 S3 G3 D3 B.t17 sky130_fd_pr__pfet_01v8 ad=1.45 pd=10.58 as=1.45 ps=10.58 w=5 l=0.5
X3 S12 G12 D12 B.t4 sky130_fd_pr__pfet_01v8 ad=1.45 pd=10.58 as=1.45 ps=10.58 w=5 l=0.5
X4 S10 G10 D10 B.t16 sky130_fd_pr__pfet_01v8 ad=1.45 pd=10.58 as=1.45 ps=10.58 w=5 l=0.5
X5 S16 G16 D16 B.t1 sky130_fd_pr__pfet_01v8 ad=1.45 pd=10.58 as=1.45 ps=10.58 w=5 l=0.5
X6 S14 G14 D14 B.t10 sky130_fd_pr__pfet_01v8 ad=1.45 pd=10.58 as=1.45 ps=10.58 w=5 l=0.5
X7 S6 G6 D6 B.t14 sky130_fd_pr__pfet_01v8 ad=1.45 pd=10.58 as=1.45 ps=10.58 w=5 l=0.5
X8 S8 G8 D8 B.t19 sky130_fd_pr__pfet_01v8 ad=1.45 pd=10.58 as=1.45 ps=10.58 w=5 l=0.5
X9 S19 G19 D19 B.t9 sky130_fd_pr__pfet_01v8 ad=1.45 pd=10.58 as=1.45 ps=10.58 w=5 l=0.5
X10 S0 G0 D0 B.t8 sky130_fd_pr__pfet_01v8 ad=1.45 pd=10.58 as=1.45 ps=10.58 w=5 l=0.5
X11 S13 G13 D13 B.t12 sky130_fd_pr__pfet_01v8 ad=1.45 pd=10.58 as=1.45 ps=10.58 w=5 l=0.5
X12 S11 G11 D11 B.t6 sky130_fd_pr__pfet_01v8 ad=1.45 pd=10.58 as=1.45 ps=10.58 w=5 l=0.5
X13 S9 G9 D9 B.t5 sky130_fd_pr__pfet_01v8 ad=1.45 pd=10.58 as=1.45 ps=10.58 w=5 l=0.5
X14 S18 G18 D18 B.t0 sky130_fd_pr__pfet_01v8 ad=1.45 pd=10.58 as=1.45 ps=10.58 w=5 l=0.5
X15 S4 G4 D4 B.t11 sky130_fd_pr__pfet_01v8 ad=1.45 pd=10.58 as=1.45 ps=10.58 w=5 l=0.5
X16 S2 G2 D2 B.t7 sky130_fd_pr__pfet_01v8 ad=1.45 pd=10.58 as=1.45 ps=10.58 w=5 l=0.5
X17 S1 G1 D1 B.t15 sky130_fd_pr__pfet_01v8 ad=1.45 pd=10.58 as=1.45 ps=10.58 w=5 l=0.5
X18 S15 G15 D15 B.t18 sky130_fd_pr__pfet_01v8 ad=1.45 pd=10.58 as=1.45 ps=10.58 w=5 l=0.5
X19 S7 G7 D7 B.t3 sky130_fd_pr__pfet_01v8 ad=1.45 pd=10.58 as=1.45 ps=10.58 w=5 l=0.5
R0 B.n5 B.n1 44414.1
R1 B.n2 B.t9 1397.87
R2 B.n5 B.n4 55.6541
R3 B.n2 B.n3 4280.88
R4 B.n4 B.n3 4275.52
R5 B B.n1 4737.51
R6 B.n2 B.n1 4280.88
R7 B.t15 B.t8 2386.59
R8 B.t7 B.t15 2386.59
R9 B.t17 B.t7 2386.59
R10 B.t11 B.t17 2386.59
R11 B.t13 B.t11 2386.59
R12 B.t14 B.t13 2386.59
R13 B.t3 B.t14 2386.59
R14 B.t19 B.t3 2386.59
R15 B.t5 B.t19 2386.59
R16 B.t16 B.t6 2386.59
R17 B.t6 B.t4 2386.59
R18 B.t4 B.t12 2386.59
R19 B.t12 B.t10 2386.59
R20 B.t10 B.t18 2386.59
R21 B.t18 B.t1 2386.59
R22 B.t1 B.t2 2386.59
R23 B.t2 B.t0 2386.59
R24 B.t0 B.t9 2386.59
R25 B.n5 B.t8 1347.64
R26 B.n0 B.t5 1193.29
R27 B.n0 B.t16 1193.29
R28 B B.n4 5.93733
R29 B.n0 B.n3 1.01978
R30 B.n1 B.n0 1.01978
C0 B S1 0.30476f
C1 G13 G14 0.0552f
C2 G18 S18 0.1785f
C3 S6 S7 0.0053f
C4 B G6 0.22141f
C5 S10 S9 0.0053f
C6 S5 S6 0.0053f
C7 B D14 0.30469f
C8 D4 D3 0.0053f
C9 D8 G8 0.1785f
C10 S4 D4 0.24355f
C11 G12 G11 0.0552f
C12 G5 D5 0.1785f
C13 G10 D10 0.1785f
C14 G9 G8 0.0552f
C15 B D18 0.30476f
C16 D14 D13 0.0053f
C17 D15 D16 0.0053f
C18 B D13 0.30469f
C19 S11 S12 0.0053f
C20 D10 D9 0.0053f
C21 D11 D10 0.0053f
C22 S14 D14 0.24355f
C23 D1 S1 0.24355f
C24 G17 S17 0.1785f
C25 B S14 0.30469f
C26 G2 G1 0.0552f
C27 B S18 0.30476f
C28 S5 D5 0.24355f
C29 G13 B 0.22141f
C30 D18 S18 0.24355f
C31 S5 G5 0.1785f
C32 B D1 0.30476f
C33 S9 G9 0.1785f
C34 G13 D13 0.1785f
C35 B D4 0.30469f
C36 S8 G8 0.1785f
C37 G3 G2 0.0552f
C38 G16 S16 0.1785f
C39 S2 G2 0.1785f
C40 S10 B 0.30469f
C41 D0 G0 0.1785f
C42 S13 S12 0.0053f
C43 D17 D16 0.0053f
C44 D15 S15 0.24355f
C45 D2 D3 0.0053f
C46 D7 B 0.30469f
C47 S8 S9 0.0053f
C48 G4 S4 0.1785f
C49 S2 D2 0.24355f
C50 G3 G4 0.0552f
C51 G2 B 0.22141f
C52 G16 D16 0.1785f
C53 B D8 0.30469f
C54 S9 D9 0.24355f
C55 D17 G17 0.1785f
C56 G7 S7 0.1785f
C57 B G9 0.22141f
C58 D11 D12 0.0053f
C59 S15 G15 0.1785f
C60 B S16 0.30469f
C61 D6 G6 0.1785f
C62 B D2 0.30469f
C63 B G11 0.22141f
C64 G16 G17 0.0552f
C65 D6 B 0.30469f
C66 B G4 0.22141f
C67 S11 B 0.30469f
C68 D17 S17 0.24355f
C69 B S8 0.30469f
C70 G1 G0 0.0552f
C71 G17 G18 0.0552f
C72 B G10 0.22141f
C73 B D16 0.30469f
C74 S6 G6 0.1785f
C75 S12 G12 0.1785f
C76 D2 D1 0.0053f
C77 B D9 0.30469f
C78 D11 B 0.30469f
C79 B S6 0.30469f
C80 D15 G15 0.1785f
C81 D7 D8 0.0053f
C82 G4 D4 0.1785f
C83 G7 G8 0.0552f
C84 G19 S19 0.1785f
C85 S5 S4 0.0053f
C86 S13 B 0.30469f
C87 B G17 0.22141f
C88 S0 G0 0.1785f
C89 B D5 0.30469f
C90 G5 G6 0.0552f
C91 D6 D7 0.0053f
C92 S10 S11 0.0053f
C93 S13 D13 0.24355f
C94 B G5 0.22141f
C95 B S15 0.30469f
C96 G2 D2 0.1785f
C97 S10 G10 0.1785f
C98 B G0 0.25255f
C99 S13 S14 0.0053f
C100 S12 D12 0.24355f
C101 D0 S0 0.24355f
C102 S3 D3 0.24355f
C103 G13 S13 0.1785f
C104 B S7 0.30469f
C105 G12 D12 0.1785f
C106 S3 S4 0.0053f
C107 S5 B 0.30469f
C108 G3 S3 0.1785f
C109 B S17 0.30469f
C110 G19 D19 0.1785f
C111 S14 S15 0.0053f
C112 S2 S3 0.0053f
C113 S8 D8 0.24355f
C114 G19 G18 0.0552f
C115 G16 G15 0.0552f
C116 D0 B 0.30948f
C117 D5 D4 0.0053f
C118 D15 D14 0.0053f
C119 B D10 0.30469f
C120 D8 D9 0.0053f
C121 D15 B 0.30469f
C122 S19 D19 0.24355f
C123 G10 G9 0.0552f
C124 G15 G14 0.0552f
C125 S18 S17 0.0053f
C126 S11 G11 0.1785f
C127 G9 D9 0.1785f
C128 G7 G6 0.0552f
C129 B S3 0.30469f
C130 D16 S16 0.24355f
C131 B S12 0.30469f
C132 G10 G11 0.0552f
C133 G7 B 0.22141f
C134 G19 B 0.25255f
C135 B G12 0.22141f
C136 D0 D1 0.0053f
C137 D11 G11 0.1785f
C138 D6 S6 0.24355f
C139 D7 S7 0.24355f
C140 B S19 0.30948f
C141 B G8 0.22141f
C142 S11 D11 0.24355f
C143 B G15 0.22141f
C144 G3 D3 0.1785f
C145 B D17 0.30469f
C146 S10 D10 0.24355f
C147 G13 G12 0.0552f
C148 D17 D18 0.0053f
C149 G1 S1 0.1785f
C150 D6 D5 0.0053f
C151 S15 S16 0.0053f
C152 S19 S18 0.0053f
C153 B S9 0.30469f
C154 B G1 0.22141f
C155 G4 G5 0.0552f
C156 G16 B 0.22141f
C157 B D12 0.30469f
C158 B D3 0.30469f
C159 D14 G14 0.1785f
C160 G7 D7 0.1785f
C161 B G14 0.22141f
C162 S2 S1 0.0053f
C163 S16 S17 0.0053f
C164 B S4 0.30469f
C165 B D19 0.30948f
C166 D12 D13 0.0053f
C167 G3 B 0.22141f
C168 S0 S1 0.0053f
C169 B G18 0.22141f
C170 D19 D18 0.0053f
C171 S2 B 0.30469f
C172 S7 S8 0.0053f
C173 G18 D18 0.1785f
C174 G1 D1 0.1785f
C175 S0 B 0.30948f
C176 S14 G14 0.1785f
C177 S0 VSUBS 0.16022f
C178 D0 VSUBS 0.16022f
C179 S1 VSUBS 0.14068f
C180 D1 VSUBS 0.14068f
C181 S2 VSUBS 0.14068f
C182 D2 VSUBS 0.14068f
C183 S3 VSUBS 0.14068f
C184 D3 VSUBS 0.14068f
C185 S4 VSUBS 0.14068f
C186 D4 VSUBS 0.14068f
C187 S5 VSUBS 0.14068f
C188 D5 VSUBS 0.14068f
C189 S6 VSUBS 0.14068f
C190 D6 VSUBS 0.14068f
C191 S7 VSUBS 0.14068f
C192 D7 VSUBS 0.14068f
C193 S8 VSUBS 0.14068f
C194 D8 VSUBS 0.14068f
C195 S9 VSUBS 0.14068f
C196 D9 VSUBS 0.14068f
C197 S10 VSUBS 0.14068f
C198 D10 VSUBS 0.14068f
C199 S11 VSUBS 0.14068f
C200 D11 VSUBS 0.14068f
C201 S12 VSUBS 0.14068f
C202 D12 VSUBS 0.14068f
C203 S13 VSUBS 0.14068f
C204 D13 VSUBS 0.14068f
C205 S14 VSUBS 0.14068f
C206 D14 VSUBS 0.14068f
C207 S15 VSUBS 0.14068f
C208 D15 VSUBS 0.14068f
C209 S16 VSUBS 0.14068f
C210 D16 VSUBS 0.14068f
C211 S17 VSUBS 0.14068f
C212 D17 VSUBS 0.14068f
C213 S18 VSUBS 0.14068f
C214 D18 VSUBS 0.14068f
C215 S19 VSUBS 0.16022f
C216 D19 VSUBS 0.16022f
C217 B VSUBS 46.28238f
C218 B.n0 VSUBS 0.3236f
C219 B.n1 VSUBS 0.91133f
C220 B.n2 VSUBS 1.08154f
C221 B.n3 VSUBS 0.91133f
C222 B.t8 VSUBS 0.50722f
C223 B.t9 VSUBS 0.53055f
C224 B.t0 VSUBS 0.6472f
C225 B.t2 VSUBS 0.6472f
C226 B.t1 VSUBS 0.6472f
C227 B.t18 VSUBS 0.6472f
C228 B.t10 VSUBS 0.6472f
C229 B.t12 VSUBS 0.6472f
C230 B.t4 VSUBS 0.6472f
C231 B.t6 VSUBS 0.6472f
C232 B.t16 VSUBS 0.4854f
C233 B.t15 VSUBS 0.6472f
C234 B.t7 VSUBS 0.6472f
C235 B.t17 VSUBS 0.6472f
C236 B.t11 VSUBS 0.6472f
C237 B.t13 VSUBS 0.6472f
C238 B.t14 VSUBS 0.6472f
C239 B.t3 VSUBS 0.6472f
C240 B.t19 VSUBS 0.6472f
C241 B.t5 VSUBS 0.4854f
C242 B.n5 VSUBS 0.64944f
.ends

.subckt sky130_fd_pr__cap_mim_m3_1_6ZDEYE C2 C1 w_n1216_n1040#
X0 C1 C2 sky130_fd_pr__cap_mim_m3_1 l=10 w=10
C0 C2 C1 9.25061f
C1 C2 w_n1216_n1040# 4.84784f
.ends

.subckt ldo_open vdd vss vref vout vdd.n10 vdd.n21 w_2824_2788.n1 vdd.n20 w_2824_2788.n0
+ m1_81694_94112.n9 m1_81694_94112.n8 m1_81694_94112.n7 m1_81694_94112.n6 m1_81694_94112.n5
+ m1_81694_94112.n4 m1_81694_94112.n3 m1_81694_94112.n2 m1_81694_94112.n1 m1_81694_94112.n0
+ vss.n2 vss.n1 w_2824_2788.n19 vss.n0 w_2824_2788.n29 w_2824_2788.n18 w_2824_2788.n39
+ w_2824_2788.n28 w_2824_2788.n17 vout.n9 w_2824_2788.n49 w_2824_2788.n38 w_2824_2788.n27
+ w_2824_2788.n16 vref.n0 vout.n8 w_2824_2788.n59 w_2824_2788.n48 w_2824_2788.n37
+ w_2824_2788.n26 w_2824_2788.n15 vout.n7 w_2824_2788.n58 w_2824_2788.n47 w_2824_2788.n36
+ w_2824_2788.n25 w_2824_2788.n14 vout.n6 w_2824_2788.n68 w_2824_2788.n57 w_2824_2788.n46
+ w_2824_2788.n35 w_2824_2788.n24 w_2824_2788.n13 vout.n5 w_2824_2788.n67 w_2824_2788.n56
+ w_2824_2788.n45 w_2824_2788.n34 w_2824_2788.n23 w_2824_2788.n12 vout.n4 w_2824_2788.n66
+ w_2824_2788.n55 w_2824_2788.n44 w_2824_2788.n33 w_2824_2788.n22 w_2824_2788.n11
+ vout.n19 vout.n3 w_2824_2788.n65 w_2824_2788.n54 w_2824_2788.n43 w_2824_2788.n32
+ w_2824_2788.n21 w_2824_2788.n10 vdd.n9 vout.n18 vout.n2 w_2824_2788.n64 w_2824_2788.n53
+ w_2824_2788.n42 w_2824_2788.n31 w_2824_2788.n20 vout.n17 vdd.n8 vout.n1 w_2824_2788.n63
+ w_2824_2788.n52 w_2824_2788.n41 w_2824_2788.n30 vdd.n7 vout.n16 m1_81694_94112.n19
+ vout.n0 w_2824_2788.n62 w_2824_2788.n51 w_2824_2788.n40 vout.n15 vdd.n6 m1_81694_94112.n18
+ w_2824_2788.n61 w_2824_2788.n50 vdd.n5 vout.n14 m1_81694_94112.n17 vdd.n19 w_2824_2788.n60
+ vout.n13 vdd.n4 m1_81694_94112.n16 vdd.n18 w_2824_2788.n9 vdd.n3 vout.n12 d9/B m1_81694_94112.n15
+ vdd.n17 w_2824_2788.n8 vout.n11 vdd.n2 m1_81694_94112.n14 vdd.n16 w_2824_2788.n7
+ vout.n10 vdd.n1 m1_81694_94112.n13 vdd.n15 w_2824_2788.n6 vout.n20 vdd.n0 m1_81694_94112.n12
+ vdd.n14 w_2824_2788.n5 m1_81694_94112.n11 vdd.n13 w_2824_2788.n4 vdd.n12 m1_81694_94112.n10
+ w_2824_2788.n3 m1_81694_94112.n20 vdd.n11 w_2824_2788.n2 d6/D
Xd10 d9/B d3/G vss sky130_fd_pr__res_high_po_0p35_PAVCDF
Xd0 d9/B d2/G vss d2/G sky130_fd_pr__nfet_01v8_XR83G9
Xd1 d9/B vdd d2/G sky130_fd_pr__res_high_po_0p35_5BEF7K
Xd2 d9/B d4/S vss d2/G sky130_fd_pr__nfet_01v8_AFE8E4
Xd3 d9/B d6/G d4/S d3/G sky130_fd_pr__nfet_01v8_TPXDG7
Xd4 d9/B d6/D d4/S vref sky130_fd_pr__nfet_01v8_TPXDG7
Xd5 d5/B d6/G vdd d6/G d9/B sky130_fd_pr__pfet_01v8_5KKSJS
Xd6 d6/B d6/D vdd d6/G d9/B sky130_fd_pr__pfet_01v8_5KKSJS
Xd7 d7/B vout vdd d6/D vout vdd d6/D vout vdd d6/D vout vdd d6/D vout vdd d6/D vout
+ vdd d6/D vout vdd d6/D vout vdd d6/D vout vdd d6/D vout vdd d6/D vout vdd d6/D vout
+ vdd d6/D vout vdd d6/D vout vdd d6/D vout vdd d6/D vout vdd d6/D vout vdd d6/D vout
+ vdd d6/D vout vdd d6/D vout vdd d6/D d9/B sky130_fd_pr__pfet_01v8_FYEDVJ
Xd9 d9/B vout d3/G sky130_fd_pr__res_high_po_0p35_PAVCDF
Xd8 d6/D vout d9/B sky130_fd_pr__cap_mim_m3_1_6ZDEYE
R0 vref vref.n0 3.4105
R1 vss vss.n2 682.274
R2 vss.n2 vss 82.6962
R3 vss.n1 vss 82.5396
R4 vss.n2 vss.n1 67.063
R5 vss.n1 vss.n0 13.3686
R6 vss.n0 vss 3.4105
R7 vdd.n3 vdd.n2 259.795
R8 vdd.n1 vdd.n0 164.945
R9 vdd vdd.n21 151.328
R10 vdd.n21 vdd 142.314
R11 vdd.n20 vdd 139.133
R12 vdd.n19 vdd 135.952
R13 vdd.n18 vdd 132.773
R14 vdd.n17 vdd 129.593
R15 vdd.n16 vdd 126.412
R16 vdd.n15 vdd 123.231
R17 vdd.n14 vdd 120.052
R18 vdd.n13 vdd 116.871
R19 vdd.n12 vdd 113.691
R20 vdd.n11 vdd 110.51
R21 vdd.n9 vdd 104.15
R22 vdd.n10 vdd 102.829
R23 vdd.n8 vdd 100.969
R24 vdd.n7 vdd 97.7888
R25 vdd.n6 vdd 94.6085
R26 vdd.n5 vdd 91.4281
R27 vdd.n4 vdd 88.2478
R28 vdd.n3 vdd 85.0675
R29 vdd.n2 vdd 84.9162
R30 vdd.n1 vdd 84.9162
R31 vdd.n2 vdd.n1 36.4366
R32 vdd.n4 vdd.n3 5.83522
R33 vdd.n5 vdd.n4 5.83522
R34 vdd.n6 vdd.n5 5.83522
R35 vdd.n7 vdd.n6 5.83522
R36 vdd.n8 vdd.n7 5.83522
R37 vdd.n9 vdd.n8 5.83522
R38 vdd.n10 vdd.n9 5.83522
R39 vdd.n11 vdd.n10 5.83522
R40 vdd.n12 vdd.n11 5.83522
R41 vdd.n13 vdd.n12 5.83522
R42 vdd.n14 vdd.n13 5.83522
R43 vdd.n15 vdd.n14 5.83522
R44 vdd.n16 vdd.n15 5.83522
R45 vdd.n17 vdd.n16 5.83522
R46 vdd.n18 vdd.n17 5.83522
R47 vdd.n19 vdd.n18 5.83522
R48 vdd.n20 vdd.n19 5.83522
R49 vdd.n21 vdd.n20 5.83522
R50 vdd.n0 vdd 3.4105
R51 vout.n1 vout 177.548
R52 vout.n2 vout 172.156
R53 vout.n3 vout 166.763
R54 vout.n4 vout 161.371
R55 vout.n5 vout 155.978
R56 vout.n6 vout 150.587
R57 vout.n7 vout 145.194
R58 vout.n20 vout.n19 142.177
R59 vout.n8 vout 139.802
R60 vout.n9 vout 134.409
R61 vout.n10 vout 129.017
R62 vout.n11 vout 123.624
R63 vout.n12 vout 118.231
R64 vout.n13 vout 112.838
R65 vout vout.n20 110.099
R66 vout.n14 vout 107.447
R67 vout.n15 vout 102.053
R68 vout.n16 vout 96.6615
R69 vout.n17 vout 91.269
R70 vout.n18 vout 85.8766
R71 vout.n19 vout 80.4841
R72 vout.n20 vout 69.7574
R73 vout.n1 vout.n0 11.7186
R74 vout.n2 vout.n1 11.7186
R75 vout.n3 vout.n2 11.7186
R76 vout.n4 vout.n3 11.7186
R77 vout.n5 vout.n4 11.7186
R78 vout.n6 vout.n5 11.7186
R79 vout.n7 vout.n6 11.7186
R80 vout.n8 vout.n7 11.7186
R81 vout.n9 vout.n8 11.7186
R82 vout.n10 vout.n9 11.7186
R83 vout.n11 vout.n10 11.7186
R84 vout.n12 vout.n11 11.7186
R85 vout.n13 vout.n12 11.7186
R86 vout.n14 vout.n13 11.7186
R87 vout.n15 vout.n14 11.7186
R88 vout.n16 vout.n15 11.7186
R89 vout.n17 vout.n16 11.7186
R90 vout.n18 vout.n17 11.7186
R91 vout.n19 vout.n18 11.7186
R92 vout.n0 vout 3.4105
R93 d6/D m1_81694_94112.n20 227.798
R94 m1_81694_94112.n1 d6/D 174.571
R95 m1_81694_94112.n2 d6/D 169.178
R96 m1_81694_94112.n3 d6/D 163.786
R97 m1_81694_94112.n4 d6/D 158.393
R98 m1_81694_94112.n5 d6/D 153
R99 m1_81694_94112.n6 d6/D 147.607
R100 m1_81694_94112.n0 d6/D 142.643
R101 m1_81694_94112.n7 d6/D 142.215
R102 m1_81694_94112.n8 d6/D 136.822
R103 m1_81694_94112.n9 d6/D 131.43
R104 m1_81694_94112.n10 d6/D 126.037
R105 m1_81694_94112.n11 d6/D 120.645
R106 m1_81694_94112.n12 d6/D 115.252
R107 m1_81694_94112.n13 d6/D 109.861
R108 m1_81694_94112.n14 d6/D 104.469
R109 m1_81694_94112.n15 d6/D 99.0756
R110 m1_81694_94112.n16 d6/D 93.6831
R111 m1_81694_94112.n17 d6/D 88.2906
R112 m1_81694_94112.n18 d6/D 82.8982
R113 m1_81694_94112.n19 d6/D 77.5057
R114 m1_81694_94112.n20 d6/D 72.1132
R115 m1_81694_94112.n0 d6/D 69.3183
R116 m1_81694_94112.n1 m1_81694_94112.n0 30.6019
R117 m1_81694_94112.n2 m1_81694_94112.n1 11.7186
R118 m1_81694_94112.n3 m1_81694_94112.n2 11.7186
R119 m1_81694_94112.n4 m1_81694_94112.n3 11.7186
R120 m1_81694_94112.n5 m1_81694_94112.n4 11.7186
R121 m1_81694_94112.n6 m1_81694_94112.n5 11.7186
R122 m1_81694_94112.n7 m1_81694_94112.n6 11.7186
R123 m1_81694_94112.n8 m1_81694_94112.n7 11.7186
R124 m1_81694_94112.n9 m1_81694_94112.n8 11.7186
R125 m1_81694_94112.n10 m1_81694_94112.n9 11.7186
R126 m1_81694_94112.n11 m1_81694_94112.n10 11.7186
R127 m1_81694_94112.n12 m1_81694_94112.n11 11.7186
R128 m1_81694_94112.n13 m1_81694_94112.n12 11.7186
R129 m1_81694_94112.n14 m1_81694_94112.n13 11.7186
R130 m1_81694_94112.n15 m1_81694_94112.n14 11.7186
R131 m1_81694_94112.n16 m1_81694_94112.n15 11.7186
R132 m1_81694_94112.n17 m1_81694_94112.n16 11.7186
R133 m1_81694_94112.n18 m1_81694_94112.n17 11.7186
R134 m1_81694_94112.n19 m1_81694_94112.n18 11.7186
R135 m1_81694_94112.n20 m1_81694_94112.n19 11.7186
R136 d6/D d6/D 9.30224
R137 d6/D d6/D 9.30224
R138 d6/D d6/D 9.30224
R139 d6/D d6/D 9.30224
R140 d6/D d6/D 9.30224
R141 d6/D d6/D 9.30224
R142 d6/D d6/D 9.30224
R143 d6/D d6/D 9.30224
R144 d6/D d6/D 9.30224
R145 d6/D d6/D 9.30224
R146 d6/D d6/D 9.30224
R147 d6/D d6/D 9.30224
R148 d6/D d6/D 9.30224
R149 d6/D d6/D 9.30224
R150 d6/D d6/D 9.30224
R151 d6/D d6/D 9.30224
R152 d6/D d6/D 9.30224
R153 d6/D d6/D 9.30224
R154 d6/D d6/D 9.30224
R155 d6/D d6/D 9.30224
R156 w_2824_2788.n57 w_2824_2788.n5 38588.8
R157 w_2824_2788.n54 w_2824_2788.n5 38588.8
R158 w_2824_2788.n57 w_2824_2788.n4 38588.8
R159 w_2824_2788.n54 w_2824_2788.n4 38588.8
R160 w_2824_2788.n27 w_2824_2788.n23 15412.4
R161 w_2824_2788.n25 w_2824_2788.n2 21.3694
R162 w_2824_2788.n27 w_2824_2788.n0 15412.4
R163 w_2824_2788.n33 w_2824_2788.n21 15412.4
R164 w_2824_2788.n30 w_2824_2788.n21 15412.4
R165 w_2824_2788.n33 w_2824_2788.n20 15412.4
R166 w_2824_2788.n30 w_2824_2788.n20 15412.4
R167 w_2824_2788.n35 d9/B 7896.88
R168 w_2824_2788.n39 w_2824_2788.n17 6854.44
R169 w_2824_2788.n36 w_2824_2788.n17 6854.44
R170 w_2824_2788.n39 w_2824_2788.n16 6854.44
R171 w_2824_2788.n36 w_2824_2788.n16 6854.44
R172 w_2824_2788.n45 w_2824_2788.n13 6854.44
R173 w_2824_2788.n42 w_2824_2788.n13 6854.44
R174 w_2824_2788.n45 w_2824_2788.n12 6854.44
R175 w_2824_2788.n42 w_2824_2788.n12 6854.44
R176 w_2824_2788.n51 w_2824_2788.n9 5116.21
R177 w_2824_2788.n48 w_2824_2788.n9 5116.21
R178 w_2824_2788.n51 w_2824_2788.n8 5116.21
R179 w_2824_2788.n48 w_2824_2788.n8 5116.21
R180 w_2824_2788.n64 w_2824_2788.n61 3957.38
R181 w_2824_2788.n67 w_2824_2788.n61 3957.38
R182 w_2824_2788.n64 w_2824_2788.n60 3957.38
R183 w_2824_2788.n67 w_2824_2788.n60 3957.38
R184 w_2824_2788.n56 d9/B 2507.29
R185 d9/B w_2824_2788.n55 2507.29
R186 w_2824_2788.n56 w_2824_2788.n6 2507.29
R187 w_2824_2788.n55 w_2824_2788.n6 2507.29
R188 w_2824_2788.n26 d9/B 1001.41
R189 d9/B w_2824_2788.n25 1001.41
R190 w_2824_2788.n26 w_2824_2788.n24 1001.41
R191 w_2824_2788.n25 w_2824_2788.n24 1001.41
R192 w_2824_2788.n32 d9/B 1001.41
R193 d9/B w_2824_2788.n31 1001.41
R194 w_2824_2788.n32 w_2824_2788.n22 1001.41
R195 w_2824_2788.n31 w_2824_2788.n22 1001.41
R196 d9/B w_2824_2788.n68 648.78
R197 w_2824_2788.n47 d9/B 648.78
R198 w_2824_2788.n41 d9/B 648.78
R199 w_2824_2788.n53 d9/B 541.063
R200 w_2824_2788.n29 d9/B 541.063
R201 w_2824_2788.n38 d9/B 445.365
R202 d9/B w_2824_2788.n37 445.365
R203 w_2824_2788.n38 w_2824_2788.n18 445.365
R204 w_2824_2788.n37 w_2824_2788.n18 445.365
R205 w_2824_2788.n44 d9/B 445.365
R206 d9/B w_2824_2788.n43 445.365
R207 w_2824_2788.n44 w_2824_2788.n14 445.365
R208 w_2824_2788.n43 w_2824_2788.n14 445.365
R209 w_2824_2788.n50 d9/B 332.425
R210 d9/B w_2824_2788.n49 332.425
R211 w_2824_2788.n50 w_2824_2788.n10 332.425
R212 w_2824_2788.n49 w_2824_2788.n10 332.425
R213 w_2824_2788.n4 w_2824_2788.n3 292.5
R214 w_2824_2788.n6 w_2824_2788.n4 292.5
R215 w_2824_2788.n5 w_2824_2788.n3 292.5
R216 d9/B w_2824_2788.n5 292.5
R217 w_2824_2788.n20 w_2824_2788.n19 292.5
R218 w_2824_2788.n22 w_2824_2788.n20 292.5
R219 w_2824_2788.n21 w_2824_2788.n19 292.5
R220 d9/B w_2824_2788.n21 292.5
R221 w_2824_2788.n24 w_2824_2788.n0 292.5
R222 w_2824_2788.n23 w_2824_2788.n2 286.807
R223 d9/B w_2824_2788.n23 292.5
R224 w_2824_2788.n1 w_2824_2788.n0 286.801
R225 d9/B w_2824_2788.n65 257.13
R226 w_2824_2788.n66 d9/B 257.13
R227 w_2824_2788.n65 w_2824_2788.n62 257.13
R228 w_2824_2788.n66 w_2824_2788.n62 257.13
R229 w_2824_2788.n12 w_2824_2788.n11 117.001
R230 w_2824_2788.n14 w_2824_2788.n12 117.001
R231 w_2824_2788.n13 w_2824_2788.n11 117.001
R232 d9/B w_2824_2788.n13 117.001
R233 w_2824_2788.n16 w_2824_2788.n15 117.001
R234 w_2824_2788.n18 w_2824_2788.n16 117.001
R235 w_2824_2788.n17 w_2824_2788.n15 117.001
R236 d9/B w_2824_2788.n17 117.001
R237 w_2824_2788.n60 w_2824_2788.n59 73.1255
R238 w_2824_2788.n62 w_2824_2788.n60 73.1255
R239 w_2824_2788.n68 w_2824_2788.n67 73.1255
R240 w_2824_2788.n67 w_2824_2788.n66 73.1255
R241 w_2824_2788.n61 w_2824_2788.n59 73.1255
R242 d9/B w_2824_2788.n61 73.1255
R243 w_2824_2788.n64 w_2824_2788.n63 73.1255
R244 w_2824_2788.n65 w_2824_2788.n64 73.1255
R245 w_2824_2788.n8 w_2824_2788.n7 73.1255
R246 w_2824_2788.n10 w_2824_2788.n8 73.1255
R247 w_2824_2788.n9 w_2824_2788.n7 73.1255
R248 d9/B w_2824_2788.n9 73.1255
R249 w_2824_2788.n48 w_2824_2788.n47 41.7862
R250 w_2824_2788.n49 w_2824_2788.n48 41.7862
R251 w_2824_2788.n52 w_2824_2788.n51 41.7862
R252 w_2824_2788.n51 w_2824_2788.n50 41.7862
R253 w_2824_2788.n42 w_2824_2788.n41 22.5005
R254 w_2824_2788.n43 w_2824_2788.n42 22.5005
R255 w_2824_2788.n46 w_2824_2788.n45 22.5005
R256 w_2824_2788.n45 w_2824_2788.n44 22.5005
R257 w_2824_2788.n36 w_2824_2788.n35 22.5005
R258 w_2824_2788.n37 w_2824_2788.n36 22.5005
R259 w_2824_2788.n40 w_2824_2788.n39 22.5005
R260 w_2824_2788.n39 w_2824_2788.n38 22.5005
R261 w_2824_2788.n2 w_2824_2788.n1 0.252336
R262 w_2824_2788.n63 w_2824_2788.n59 13.0929
R263 w_2824_2788.n68 w_2824_2788.n59 13.0929
R264 w_2824_2788.n52 w_2824_2788.n7 13.0929
R265 w_2824_2788.n47 w_2824_2788.n7 13.0929
R266 w_2824_2788.n46 w_2824_2788.n11 9.27587
R267 w_2824_2788.n41 w_2824_2788.n11 9.27587
R268 w_2824_2788.n40 w_2824_2788.n15 9.27587
R269 w_2824_2788.n35 w_2824_2788.n15 9.27587
R270 w_2824_2788.n30 w_2824_2788.n29 8.1255
R271 w_2824_2788.n31 w_2824_2788.n30 8.1255
R272 w_2824_2788.n34 w_2824_2788.n33 8.1255
R273 w_2824_2788.n33 w_2824_2788.n32 8.1255
R274 w_2824_2788.n28 w_2824_2788.n27 8.1255
R275 w_2824_2788.n27 w_2824_2788.n26 8.1255
R276 w_2824_2788.n28 w_2824_2788.n1 5.90651
R277 w_2824_2788.n58 w_2824_2788.n3 5.6497
R278 w_2824_2788.n53 w_2824_2788.n3 5.6497
R279 w_2824_2788.n34 w_2824_2788.n19 5.6497
R280 w_2824_2788.n29 w_2824_2788.n19 5.6497
R281 w_2824_2788.n54 w_2824_2788.n53 3.07945
R282 w_2824_2788.n55 w_2824_2788.n54 3.07945
R283 w_2824_2788.n58 w_2824_2788.n57 3.07945
R284 w_2824_2788.n57 w_2824_2788.n56 3.07945
R285 w_2824_2788.n63 d9/B 2.02352
R286 d9/B w_2824_2788.n58 2.02352
R287 d9/B w_2824_2788.n52 2.02352
R288 d9/B w_2824_2788.n46 2.02352
R289 d9/B w_2824_2788.n40 2.02352
R290 d9/B w_2824_2788.n34 2.02352
R291 d9/B w_2824_2788.n28 2.02352
C0 d6/D d7/B 1.2228f
C1 d4/S d6/D 0.10323f
C2 vdd d3/G 1.82908f
C3 d4/S vss 0.52704f
C4 vdd vout 2.79751f
C5 vss d3/G 0.28211f
C6 d6/D vref 0.3519f
C7 vout d6/D 0.13907p
C8 vref vss 0.02389f
C9 vout vss 0.03873f
C10 vdd d6/G 0.53094f
C11 d6/G d6/D 0.71998f
C12 d6/G vss 0.28758f
C13 d5/B d6/G 0.10594f
C14 vdd d2/G 0.07316f
C15 d6/G d6/B 0.05302f
C16 d4/S d3/G 0.20542f
C17 vdd d6/D 3.68249f
C18 vss d2/G 0.70023f
C19 vdd vss 1.90224f
C20 d4/S vref 0.13226f
C21 vout d7/B 1.42325f
C22 vdd d5/B 0.15383f
C23 d6/D vss 0.21442f
C24 vdd d6/B 0.15383f
C25 vref d3/G 0.07316f
C26 vout d3/G 1.60959f
C27 d4/S d6/G 0.17639f
C28 d6/D d6/B 0.05292f
C29 d6/G d3/G 0.60583f
C30 vdd d7/B 1.90598f
C31 d4/S d2/G 0.55857f
C32 d6/G vref 0.07316f
C33 w_2824_2788.n0 d9/B 0
C34 w_2824_2788.n1 d9/B 0.02979f
C35 w_2824_2788.n2 d9/B 0.00269f
C36 w_2824_2788.n3 d9/B 0.01978f
C37 w_2824_2788.n4 d9/B 0
C38 w_2824_2788.n5 d9/B 0
C39 w_2824_2788.n6 d9/B 0
C40 w_2824_2788.n7 d9/B 0.04584f
C41 w_2824_2788.n8 d9/B 0
C42 w_2824_2788.n9 d9/B 0
C43 w_2824_2788.n10 d9/B 0
C44 w_2824_2788.n11 d9/B 0.03248f
C45 w_2824_2788.n12 d9/B 0
C46 w_2824_2788.n13 d9/B 0
C47 w_2824_2788.n14 d9/B 0
C48 w_2824_2788.n15 d9/B 0.03248f
C49 w_2824_2788.n16 d9/B 0
C50 w_2824_2788.n17 d9/B 0
C51 w_2824_2788.n18 d9/B 0
C52 w_2824_2788.n19 d9/B 0.01978f
C53 w_2824_2788.n20 d9/B 0
C54 w_2824_2788.n21 d9/B 0
C55 w_2824_2788.n22 d9/B 0
C56 w_2824_2788.n23 d9/B 0
C57 w_2824_2788.n24 d9/B 0
C58 w_2824_2788.n25 d9/B 0.00448f
C59 w_2824_2788.n26 d9/B 0
C60 w_2824_2788.n27 d9/B 0
C61 w_2824_2788.n28 d9/B 0.01343f
C62 w_2824_2788.n29 d9/B 0.95709f
C63 w_2824_2788.n30 d9/B 0
C64 w_2824_2788.n31 d9/B 0
C65 w_2824_2788.n32 d9/B 0
C66 w_2824_2788.n33 d9/B 0
C67 w_2824_2788.n34 d9/B 0.01343f
C68 w_2824_2788.n35 d9/B 5.26299f
C69 w_2824_2788.n36 d9/B 0
C70 w_2824_2788.n37 d9/B 0
C71 w_2824_2788.n38 d9/B 0
C72 w_2824_2788.n39 d9/B 0
C73 w_2824_2788.n40 d9/B 0.01978f
C74 w_2824_2788.n41 d9/B 1.15201f
C75 w_2824_2788.n42 d9/B 0
C76 w_2824_2788.n43 d9/B 0
C77 w_2824_2788.n44 d9/B 0
C78 w_2824_2788.n45 d9/B 0
C79 w_2824_2788.n46 d9/B 0.01978f
C80 w_2824_2788.n47 d9/B 1.15869f
C81 w_2824_2788.n48 d9/B 0
C82 w_2824_2788.n49 d9/B 0
C83 w_2824_2788.n50 d9/B 0
C84 w_2824_2788.n51 d9/B 0
C85 w_2824_2788.n52 d9/B 0.02646f
C86 w_2824_2788.n53 d9/B 0.95709f
C87 w_2824_2788.n54 d9/B 0
C88 w_2824_2788.n55 d9/B 0
C89 w_2824_2788.n56 d9/B 0
C90 w_2824_2788.n57 d9/B 0
C91 w_2824_2788.n58 d9/B 0.01343f
C92 w_2824_2788.n59 d9/B 0.04584f
C93 w_2824_2788.n60 d9/B 0
C94 w_2824_2788.n61 d9/B 0
C95 w_2824_2788.n62 d9/B 0
C96 w_2824_2788.n63 d9/B 0.02646f
C97 w_2824_2788.n64 d9/B 0
C98 w_2824_2788.n65 d9/B 0
C99 w_2824_2788.n66 d9/B 0
C100 w_2824_2788.n67 d9/B 0
C101 w_2824_2788.n68 d9/B 1.15869f
C102 m1_81694_94112.n0 d9/B 3.81943f
C103 m1_81694_94112.n1 d9/B 4.77049f
C104 m1_81694_94112.n2 d9/B 4.44587f
C105 m1_81694_94112.n3 d9/B 4.3056f
C106 m1_81694_94112.n4 d9/B 4.1653f
C107 m1_81694_94112.n5 d9/B 4.02499f
C108 m1_81694_94112.n6 d9/B 3.88466f
C109 m1_81694_94112.n7 d9/B 3.7443f
C110 m1_81694_94112.n8 d9/B 3.60391f
C111 m1_81694_94112.n9 d9/B 3.46349f
C112 m1_81694_94112.n10 d9/B 3.32304f
C113 m1_81694_94112.n11 d9/B 3.18255f
C114 m1_81694_94112.n12 d9/B 3.04202f
C115 m1_81694_94112.n13 d9/B 2.90144f
C116 m1_81694_94112.n14 d9/B 2.76079f
C117 m1_81694_94112.n15 d9/B 2.62008f
C118 m1_81694_94112.n16 d9/B 2.47929f
C119 m1_81694_94112.n17 d9/B 2.33841f
C120 m1_81694_94112.n18 d9/B 2.19741f
C121 m1_81694_94112.n19 d9/B 2.05627f
C122 m1_81694_94112.n20 d9/B 4.28933f
C123 vout.n0 d9/B 0.22312f
C124 vout.n1 d9/B 4.50641f
C125 vout.n2 d9/B 4.37088f
C126 vout.n3 d9/B 4.23533f
C127 vout.n4 d9/B 4.09977f
C128 vout.n5 d9/B 3.96419f
C129 vout.n6 d9/B 3.82859f
C130 vout.n7 d9/B 3.69296f
C131 vout.n8 d9/B 3.55732f
C132 vout.n9 d9/B 3.42164f
C133 vout.n10 d9/B 3.28593f
C134 vout.n11 d9/B 3.15019f
C135 vout.n12 d9/B 3.01441f
C136 vout.n13 d9/B 2.87858f
C137 vout.n14 d9/B 2.7427f
C138 vout.n15 d9/B 2.60676f
C139 vout.n16 d9/B 2.47074f
C140 vout.n17 d9/B 2.33464f
C141 vout.n18 d9/B 2.19844f
C142 vout.n19 d9/B 3.29288f
C143 vout.n20 d9/B 4.88876f
C144 vdd.n0 d9/B 0.13022f
C145 vdd.n1 d9/B 0.56961f
C146 vdd.n2 d9/B 0.48592f
C147 vdd.n3 d9/B 0.53017f
C148 vdd.n4 d9/B 0.14279f
C149 vdd.n5 d9/B 0.14813f
C150 vdd.n6 d9/B 0.15346f
C151 vdd.n7 d9/B 0.1588f
C152 vdd.n8 d9/B 0.16413f
C153 vdd.n9 d9/B 0.16946f
C154 vdd.n10 d9/B 0.16804f
C155 vdd.n11 d9/B 0.18012f
C156 vdd.n12 d9/B 0.18545f
C157 vdd.n13 d9/B 0.19077f
C158 vdd.n14 d9/B 0.1961f
C159 vdd.n15 d9/B 0.20142f
C160 vdd.n16 d9/B 0.20674f
C161 vdd.n17 d9/B 0.21207f
C162 vdd.n18 d9/B 0.21739f
C163 vdd.n19 d9/B 0.22271f
C164 vdd.n20 d9/B 0.22803f
C165 vdd.n21 d9/B 0.46636f
C166 vss.n0 d9/B 0.01931f
C167 vss.n1 d9/B 0.50758f
C168 vss.n2 d9/B 1.68955f
C169 vref.n0 d9/B 0.02677f
C170 d3/G d9/B 0.21639p
C171 vout d9/B 1.25572p
C172 d7/B d9/B 8.25272f
C173 d6/D d9/B 1.19337p
C174 d6/B d9/B 0.55523f
C175 vdd d9/B 1.41588p
C176 d6/G d9/B 0.15855p
C177 d5/B d9/B 0.55523f
C178 vref d9/B 43.05567f
C179 d4/S d9/B 0.12329p
C180 vss d9/B 0.53205p
C181 d2/G d9/B 0.16021p
.ends
